* NGSPICE file created from Slave.ext - technology: sky130A

* Black-box entry subcircuit for sky130_fd_sc_hd__decap_3 abstract view
.subckt sky130_fd_sc_hd__decap_3 VGND VNB VPB VPWR
.ends

* Black-box entry subcircuit for sky130_fd_sc_hd__and2_1 abstract view
.subckt sky130_fd_sc_hd__and2_1 A B VGND VNB VPB VPWR X
.ends

* Black-box entry subcircuit for sky130_fd_sc_hd__fill_1 abstract view
.subckt sky130_fd_sc_hd__fill_1 VGND VNB VPB VPWR
.ends

* Black-box entry subcircuit for sky130_fd_sc_hd__mux2_1 abstract view
.subckt sky130_fd_sc_hd__mux2_1 A0 A1 S VGND VNB VPB VPWR X
.ends

* Black-box entry subcircuit for sky130_fd_sc_hd__decap_4 abstract view
.subckt sky130_fd_sc_hd__decap_4 VGND VNB VPB VPWR
.ends

* Black-box entry subcircuit for sky130_fd_sc_hd__dlygate4sd3_1 abstract view
.subckt sky130_fd_sc_hd__dlygate4sd3_1 A VGND VNB VPB VPWR X
.ends

* Black-box entry subcircuit for sky130_fd_sc_hd__decap_8 abstract view
.subckt sky130_fd_sc_hd__decap_8 VGND VNB VPB VPWR
.ends

* Black-box entry subcircuit for sky130_fd_sc_hd__decap_6 abstract view
.subckt sky130_fd_sc_hd__decap_6 VGND VNB VPB VPWR
.ends

* Black-box entry subcircuit for sky130_fd_sc_hd__tapvpwrvgnd_1 abstract view
.subckt sky130_fd_sc_hd__tapvpwrvgnd_1 VGND VPWR
.ends

* Black-box entry subcircuit for sky130_fd_sc_hd__buf_2 abstract view
.subckt sky130_fd_sc_hd__buf_2 A VGND VNB VPB VPWR X
.ends

* Black-box entry subcircuit for sky130_fd_sc_hd__clkbuf_16 abstract view
.subckt sky130_fd_sc_hd__clkbuf_16 A VGND VNB VPB VPWR X
.ends

* Black-box entry subcircuit for sky130_fd_sc_hd__a22o_1 abstract view
.subckt sky130_fd_sc_hd__a22o_1 A1 A2 B1 B2 VGND VNB VPB VPWR X
.ends

* Black-box entry subcircuit for sky130_fd_sc_hd__fill_2 abstract view
.subckt sky130_fd_sc_hd__fill_2 VGND VNB VPB VPWR
.ends

* Black-box entry subcircuit for sky130_ef_sc_hd__decap_12 abstract view
.subckt sky130_ef_sc_hd__decap_12 VPWR VGND VPB VNB
.ends

* Black-box entry subcircuit for sky130_fd_sc_hd__clkbuf_4 abstract view
.subckt sky130_fd_sc_hd__clkbuf_4 A VGND VNB VPB VPWR X
.ends

* Black-box entry subcircuit for sky130_fd_sc_hd__and3b_2 abstract view
.subckt sky130_fd_sc_hd__and3b_2 A_N B C VGND VNB VPB VPWR X
.ends

* Black-box entry subcircuit for sky130_fd_sc_hd__clkinv_2 abstract view
.subckt sky130_fd_sc_hd__clkinv_2 A VGND VNB VPB VPWR Y
.ends

* Black-box entry subcircuit for sky130_fd_sc_hd__dfrtp_1 abstract view
.subckt sky130_fd_sc_hd__dfrtp_1 CLK D RESET_B VGND VNB VPB VPWR Q
.ends

* Black-box entry subcircuit for sky130_fd_sc_hd__clkinvlp_4 abstract view
.subckt sky130_fd_sc_hd__clkinvlp_4 A VGND VNB VPB VPWR Y
.ends

* Black-box entry subcircuit for sky130_fd_sc_hd__a221o_1 abstract view
.subckt sky130_fd_sc_hd__a221o_1 A1 A2 B1 B2 C1 VGND VNB VPB VPWR X
.ends

* Black-box entry subcircuit for sky130_fd_sc_hd__nand3_1 abstract view
.subckt sky130_fd_sc_hd__nand3_1 A B C VGND VNB VPB VPWR Y
.ends

* Black-box entry subcircuit for sky130_fd_sc_hd__dfrtp_4 abstract view
.subckt sky130_fd_sc_hd__dfrtp_4 CLK D RESET_B VGND VNB VPB VPWR Q
.ends

* Black-box entry subcircuit for sky130_fd_sc_hd__nor2_2 abstract view
.subckt sky130_fd_sc_hd__nor2_2 A B VGND VNB VPB VPWR Y
.ends

* Black-box entry subcircuit for sky130_fd_sc_hd__o21ai_1 abstract view
.subckt sky130_fd_sc_hd__o21ai_1 A1 A2 B1 VGND VNB VPB VPWR Y
.ends

* Black-box entry subcircuit for sky130_fd_sc_hd__dfrtp_2 abstract view
.subckt sky130_fd_sc_hd__dfrtp_2 CLK D RESET_B VGND VNB VPB VPWR Q
.ends

* Black-box entry subcircuit for sky130_fd_sc_hd__or2_1 abstract view
.subckt sky130_fd_sc_hd__or2_1 A B VGND VNB VPB VPWR X
.ends

* Black-box entry subcircuit for sky130_fd_sc_hd__o21ba_1 abstract view
.subckt sky130_fd_sc_hd__o21ba_1 A1 A2 B1_N VGND VNB VPB VPWR X
.ends

* Black-box entry subcircuit for sky130_fd_sc_hd__dfstp_1 abstract view
.subckt sky130_fd_sc_hd__dfstp_1 CLK D SET_B VGND VNB VPB VPWR Q
.ends

* Black-box entry subcircuit for sky130_fd_sc_hd__clkbuf_1 abstract view
.subckt sky130_fd_sc_hd__clkbuf_1 A VGND VNB VPB VPWR X
.ends

* Black-box entry subcircuit for sky130_fd_sc_hd__a21o_1 abstract view
.subckt sky130_fd_sc_hd__a21o_1 A1 A2 B1 VGND VNB VPB VPWR X
.ends

* Black-box entry subcircuit for sky130_fd_sc_hd__nand2_1 abstract view
.subckt sky130_fd_sc_hd__nand2_1 A B VGND VNB VPB VPWR Y
.ends

* Black-box entry subcircuit for sky130_fd_sc_hd__or3_1 abstract view
.subckt sky130_fd_sc_hd__or3_1 A B C VGND VNB VPB VPWR X
.ends

* Black-box entry subcircuit for sky130_fd_sc_hd__or4_4 abstract view
.subckt sky130_fd_sc_hd__or4_4 A B C D VGND VNB VPB VPWR X
.ends

* Black-box entry subcircuit for sky130_fd_sc_hd__a32o_1 abstract view
.subckt sky130_fd_sc_hd__a32o_1 A1 A2 A3 B1 B2 VGND VNB VPB VPWR X
.ends

* Black-box entry subcircuit for sky130_fd_sc_hd__nor2_1 abstract view
.subckt sky130_fd_sc_hd__nor2_1 A B VGND VNB VPB VPWR Y
.ends

* Black-box entry subcircuit for sky130_fd_sc_hd__nand2b_2 abstract view
.subckt sky130_fd_sc_hd__nand2b_2 A_N B VGND VNB VPB VPWR Y
.ends

* Black-box entry subcircuit for sky130_fd_sc_hd__a21oi_1 abstract view
.subckt sky130_fd_sc_hd__a21oi_1 A1 A2 B1 VGND VNB VPB VPWR Y
.ends

* Black-box entry subcircuit for sky130_fd_sc_hd__a311o_4 abstract view
.subckt sky130_fd_sc_hd__a311o_4 A1 A2 A3 B1 C1 VGND VNB VPB VPWR X
.ends

* Black-box entry subcircuit for sky130_fd_sc_hd__inv_2 abstract view
.subckt sky130_fd_sc_hd__inv_2 A VGND VNB VPB VPWR Y
.ends

* Black-box entry subcircuit for sky130_fd_sc_hd__clkbuf_2 abstract view
.subckt sky130_fd_sc_hd__clkbuf_2 A VGND VNB VPB VPWR X
.ends

* Black-box entry subcircuit for sky130_fd_sc_hd__buf_1 abstract view
.subckt sky130_fd_sc_hd__buf_1 A VGND VNB VPB VPWR X
.ends

* Black-box entry subcircuit for sky130_fd_sc_hd__a211o_1 abstract view
.subckt sky130_fd_sc_hd__a211o_1 A1 A2 B1 C1 VGND VNB VPB VPWR X
.ends

* Black-box entry subcircuit for sky130_fd_sc_hd__nor3b_1 abstract view
.subckt sky130_fd_sc_hd__nor3b_1 A B C_N VGND VNB VPB VPWR Y
.ends

* Black-box entry subcircuit for sky130_fd_sc_hd__o211a_1 abstract view
.subckt sky130_fd_sc_hd__o211a_1 A1 A2 B1 C1 VGND VNB VPB VPWR X
.ends

* Black-box entry subcircuit for sky130_fd_sc_hd__or4_1 abstract view
.subckt sky130_fd_sc_hd__or4_1 A B C D VGND VNB VPB VPWR X
.ends

* Black-box entry subcircuit for sky130_fd_sc_hd__nand2b_4 abstract view
.subckt sky130_fd_sc_hd__nand2b_4 A_N B VGND VNB VPB VPWR Y
.ends

* Black-box entry subcircuit for sky130_fd_sc_hd__a31o_1 abstract view
.subckt sky130_fd_sc_hd__a31o_1 A1 A2 A3 B1 VGND VNB VPB VPWR X
.ends

.subckt Slave VGND VPWR clkin data_in[0] data_in[1] data_in[2] data_in[3] data_in[4]
+ data_in[5] data_in[6] data_in[7] data_out[0] data_out[1] data_out[2] data_out[3]
+ data_out[4] data_out[5] data_out[6] data_out[7] reset sclk sdi sdo slave_select_in
XPHY_EDGE_ROW_4_Left_24 VGND VGND VPWR VPWR sky130_fd_sc_hd__decap_3
X_131_ net22 shiftreg_rx\[1\] VGND VGND VPWR VPWR _046_ sky130_fd_sc_hd__and2_1
XFILLER_0_57 VGND VGND VPWR VPWR sky130_fd_sc_hd__decap_3
XFILLER_17_9 VGND VGND VPWR VPWR sky130_fd_sc_hd__fill_1
XFILLER_15_6 VGND VGND VPWR VPWR sky130_fd_sc_hd__fill_1
X_114_ _036_ net46 _033_ VGND VGND VPWR VPWR _016_ sky130_fd_sc_hd__mux2_1
XFILLER_18_53 VGND VGND VPWR VPWR sky130_fd_sc_hd__decap_4
Xhold30 shiftreg_rx\[1\] VGND VGND VPWR VPWR net57 sky130_fd_sc_hd__dlygate4sd3_1
XFILLER_6_56 VGND VGND VPWR VPWR sky130_fd_sc_hd__fill_1
XFILLER_6_67 VGND VGND VPWR VPWR sky130_fd_sc_hd__decap_8
XFILLER_13_3 VGND VGND VPWR VPWR sky130_fd_sc_hd__decap_6
XFILLER_15_76 VGND VGND VPWR VPWR sky130_fd_sc_hd__decap_8
XTAP_TAPCELL_ROW_2_46 VGND VPWR sky130_fd_sc_hd__tapvpwrvgnd_1
Xoutput20 net20 VGND VGND VPWR VPWR data_out[7] sky130_fd_sc_hd__buf_2
XFILLER_3_57 VGND VGND VPWR VPWR sky130_fd_sc_hd__fill_1
XTAP_TAPCELL_ROW_12_66 VGND VPWR sky130_fd_sc_hd__tapvpwrvgnd_1
X_130_ _045_ net57 _043_ VGND VGND VPWR VPWR _023_ sky130_fd_sc_hd__mux2_1
XPHY_EDGE_ROW_12_Right_12 VGND VGND VPWR VPWR sky130_fd_sc_hd__decap_3
Xclkbuf_2_3__f_clkin clknet_0_clkin VGND VGND VPWR VPWR clknet_2_3__leaf_clkin sky130_fd_sc_hd__clkbuf_16
X_113_ net3 _059_ _034_ shiftreg_tx\[1\] VGND VGND VPWR VPWR _036_ sky130_fd_sc_hd__a22o_1
XFILLER_18_43 VGND VGND VPWR VPWR sky130_fd_sc_hd__fill_1
Xhold31 shiftreg_rx\[2\] VGND VGND VPWR VPWR net58 sky130_fd_sc_hd__dlygate4sd3_1
Xhold20 shiftreg_tx\[1\] VGND VGND VPWR VPWR net47 sky130_fd_sc_hd__dlygate4sd3_1
XPHY_EDGE_ROW_6_Right_6 VGND VGND VPWR VPWR sky130_fd_sc_hd__decap_3
Xoutput21 net21 VGND VGND VPWR VPWR sdo sky130_fd_sc_hd__buf_2
XTAP_TAPCELL_ROW_2_47 VGND VPWR sky130_fd_sc_hd__tapvpwrvgnd_1
XFILLER_13_113 VGND VGND VPWR VPWR sky130_fd_sc_hd__fill_2
XTAP_TAPCELL_ROW_12_67 VGND VPWR sky130_fd_sc_hd__tapvpwrvgnd_1
XFILLER_3_3 VPWR VGND VPWR VGND sky130_ef_sc_hd__decap_12
XFILLER_0_15 VPWR VGND VPWR VGND sky130_ef_sc_hd__decap_12
X_112_ _035_ net47 _033_ VGND VGND VPWR VPWR _015_ sky130_fd_sc_hd__mux2_1
XFILLER_18_33 VGND VGND VPWR VPWR sky130_fd_sc_hd__fill_1
Xhold10 net15 VGND VGND VPWR VPWR net37 sky130_fd_sc_hd__dlygate4sd3_1
Xhold21 shiftreg_tx\[3\] VGND VGND VPWR VPWR net48 sky130_fd_sc_hd__dlygate4sd3_1
XFILLER_12_57 VGND VGND VPWR VPWR sky130_fd_sc_hd__fill_1
XTAP_TAPCELL_ROW_8_58 VGND VPWR sky130_fd_sc_hd__tapvpwrvgnd_1
XFILLER_0_27 VGND VGND VPWR VPWR sky130_fd_sc_hd__fill_1
XPHY_EDGE_ROW_8_Left_28 VGND VGND VPWR VPWR sky130_fd_sc_hd__decap_3
XTAP_TAPCELL_ROW_18_78 VGND VPWR sky130_fd_sc_hd__tapvpwrvgnd_1
X_111_ net2 _059_ _034_ shiftreg_tx\[0\] VGND VGND VPWR VPWR _035_ sky130_fd_sc_hd__a22o_1
Xhold22 shiftreg_tx\[5\] VGND VGND VPWR VPWR net49 sky130_fd_sc_hd__dlygate4sd3_1
XFILLER_6_15 VGND VGND VPWR VPWR sky130_fd_sc_hd__decap_4
Xhold11 _008_ VGND VGND VPWR VPWR net38 sky130_fd_sc_hd__dlygate4sd3_1
XFILLER_6_48 VGND VGND VPWR VPWR sky130_fd_sc_hd__decap_8
XTAP_TAPCELL_ROW_8_59 VGND VPWR sky130_fd_sc_hd__tapvpwrvgnd_1
XFILLER_18_57 VGND VGND VPWR VPWR sky130_fd_sc_hd__fill_1
XTAP_TAPCELL_ROW_18_79 VGND VPWR sky130_fd_sc_hd__tapvpwrvgnd_1
Xclkload0 clknet_2_0__leaf_clkin VGND VGND VPWR VPWR clkload0/X sky130_fd_sc_hd__clkbuf_4
X_110_ state\[1\] net23 state\[2\] VGND VGND VPWR VPWR _034_ sky130_fd_sc_hd__and3b_2
Xhold12 net14 VGND VGND VPWR VPWR net39 sky130_fd_sc_hd__dlygate4sd3_1
Xhold23 shiftreg_tx\[4\] VGND VGND VPWR VPWR net50 sky130_fd_sc_hd__dlygate4sd3_1
XFILLER_10_80 VGND VGND VPWR VPWR sky130_fd_sc_hd__decap_4
Xoutput13 net13 VGND VGND VPWR VPWR data_out[0] sky130_fd_sc_hd__buf_2
XPHY_EDGE_ROW_11_Left_31 VGND VGND VPWR VPWR sky130_fd_sc_hd__decap_3
XPHY_EDGE_ROW_19_Right_19 VGND VGND VPWR VPWR sky130_fd_sc_hd__decap_3
XFILLER_0_29 VGND VGND VPWR VPWR sky130_fd_sc_hd__fill_1
XFILLER_1_3 VPWR VGND VPWR VGND sky130_ef_sc_hd__decap_12
Xclkload1 clknet_2_1__leaf_clkin VGND VGND VPWR VPWR clkload1/Y sky130_fd_sc_hd__clkinv_2
XFILLER_1_61 VGND VGND VPWR VPWR sky130_fd_sc_hd__fill_1
X_169_ clknet_2_0__leaf_clkin _025_ net23 VGND VGND VPWR VPWR shiftreg_rx\[3\] sky130_fd_sc_hd__dfrtp_1
Xhold13 _007_ VGND VGND VPWR VPWR net40 sky130_fd_sc_hd__dlygate4sd3_1
Xhold24 shiftreg_tx\[6\] VGND VGND VPWR VPWR net51 sky130_fd_sc_hd__dlygate4sd3_1
Xoutput14 net14 VGND VGND VPWR VPWR data_out[1] sky130_fd_sc_hd__buf_2
XFILLER_10_109 VGND VGND VPWR VPWR sky130_fd_sc_hd__fill_2
XFILLER_12_27 VGND VGND VPWR VPWR sky130_fd_sc_hd__fill_1
XFILLER_5_113 VGND VGND VPWR VPWR sky130_fd_sc_hd__fill_2
XFILLER_4_83 VGND VGND VPWR VPWR sky130_fd_sc_hd__fill_1
XTAP_TAPCELL_ROW_0_40 VGND VPWR sky130_fd_sc_hd__tapvpwrvgnd_1
XTAP_TAPCELL_ROW_9_60 VGND VPWR sky130_fd_sc_hd__tapvpwrvgnd_1
Xclkload2 clknet_2_3__leaf_clkin VGND VGND VPWR VPWR clkload2/Y sky130_fd_sc_hd__clkinvlp_4
XFILLER_18_15 VGND VGND VPWR VPWR sky130_fd_sc_hd__decap_3
X_168_ clknet_2_0__leaf_clkin _024_ net22 VGND VGND VPWR VPWR shiftreg_rx\[2\] sky130_fd_sc_hd__dfrtp_1
X_099_ shiftreg_rx\[1\] net39 _062_ VGND VGND VPWR VPWR _007_ sky130_fd_sc_hd__mux2_1
Xhold25 shiftreg_rx\[6\] VGND VGND VPWR VPWR net52 sky130_fd_sc_hd__dlygate4sd3_1
Xhold14 net13 VGND VGND VPWR VPWR net41 sky130_fd_sc_hd__dlygate4sd3_1
XFILLER_13_9 VGND VGND VPWR VPWR sky130_fd_sc_hd__fill_1
XTAP_TAPCELL_ROW_19_80 VGND VPWR sky130_fd_sc_hd__tapvpwrvgnd_1
XPHY_EDGE_ROW_1_Right_1 VGND VGND VPWR VPWR sky130_fd_sc_hd__decap_3
Xoutput15 net15 VGND VGND VPWR VPWR data_out[2] sky130_fd_sc_hd__buf_2
XFILLER_7_50 VGND VGND VPWR VPWR sky130_fd_sc_hd__decap_6
XFILLER_16_81 VGND VGND VPWR VPWR sky130_fd_sc_hd__decap_3
XTAP_TAPCELL_ROW_0_41 VGND VPWR sky130_fd_sc_hd__tapvpwrvgnd_1
XTAP_TAPCELL_ROW_9_61 VGND VPWR sky130_fd_sc_hd__tapvpwrvgnd_1
XFILLER_13_82 VGND VGND VPWR VPWR sky130_fd_sc_hd__fill_1
Xclkbuf_0_clkin clkin VGND VGND VPWR VPWR clknet_0_clkin sky130_fd_sc_hd__clkbuf_16
XFILLER_18_27 VGND VGND VPWR VPWR sky130_fd_sc_hd__fill_1
X_167_ clknet_2_0__leaf_clkin _023_ net23 VGND VGND VPWR VPWR shiftreg_rx\[1\] sky130_fd_sc_hd__dfrtp_1
X_098_ shiftreg_rx\[0\] net41 _062_ VGND VGND VPWR VPWR _006_ sky130_fd_sc_hd__mux2_1
XFILLER_19_113 VGND VGND VPWR VPWR sky130_fd_sc_hd__fill_2
XTAP_TAPCELL_ROW_19_81 VGND VPWR sky130_fd_sc_hd__tapvpwrvgnd_1
Xhold26 shiftreg_rx\[3\] VGND VGND VPWR VPWR net53 sky130_fd_sc_hd__dlygate4sd3_1
XFILLER_6_19 VGND VGND VPWR VPWR sky130_fd_sc_hd__fill_1
Xhold15 _006_ VGND VGND VPWR VPWR net42 sky130_fd_sc_hd__dlygate4sd3_1
Xoutput16 net16 VGND VGND VPWR VPWR data_out[3] sky130_fd_sc_hd__buf_2
XPHY_EDGE_ROW_15_Left_35 VGND VGND VPWR VPWR sky130_fd_sc_hd__decap_3
XPHY_EDGE_ROW_15_Right_15 VGND VGND VPWR VPWR sky130_fd_sc_hd__decap_3
XTAP_TAPCELL_ROW_0_42 VGND VPWR sky130_fd_sc_hd__tapvpwrvgnd_1
XFILLER_13_50 VGND VGND VPWR VPWR sky130_fd_sc_hd__fill_1
XPHY_EDGE_ROW_3_Left_23 VGND VGND VPWR VPWR sky130_fd_sc_hd__decap_3
XFILLER_1_53 VGND VGND VPWR VPWR sky130_fd_sc_hd__decap_3
X_166_ clknet_2_2__leaf_clkin _022_ net22 VGND VGND VPWR VPWR shiftreg_rx\[0\] sky130_fd_sc_hd__dfrtp_1
X_097_ datacounter\[2\] _066_ _067_ _030_ net12 VGND VGND VPWR VPWR _005_ sky130_fd_sc_hd__a221o_1
XTAP_TAPCELL_ROW_19_82 VGND VPWR sky130_fd_sc_hd__tapvpwrvgnd_1
Xhold16 net16 VGND VGND VPWR VPWR net43 sky130_fd_sc_hd__dlygate4sd3_1
Xhold27 shiftreg_rx\[4\] VGND VGND VPWR VPWR net54 sky130_fd_sc_hd__dlygate4sd3_1
XTAP_TAPCELL_ROW_10_62 VGND VPWR sky130_fd_sc_hd__tapvpwrvgnd_1
X_149_ clknet_2_1__leaf_clkin net10 net24 VGND VGND VPWR VPWR rx sky130_fd_sc_hd__dfrtp_1
Xoutput17 net17 VGND VGND VPWR VPWR data_out[4] sky130_fd_sc_hd__buf_2
XTAP_TAPCELL_ROW_0_43 VGND VPWR sky130_fd_sc_hd__tapvpwrvgnd_1
XFILLER_18_29 VGND VGND VPWR VPWR sky130_fd_sc_hd__decap_4
X_096_ state\[2\] _055_ _070_ VGND VGND VPWR VPWR _030_ sky130_fd_sc_hd__nand3_1
X_165_ clknet_2_3__leaf_clkin _021_ net25 VGND VGND VPWR VPWR shiftreg_tx\[7\] sky130_fd_sc_hd__dfrtp_1
XTAP_TAPCELL_ROW_19_83 VGND VPWR sky130_fd_sc_hd__tapvpwrvgnd_1
Xhold17 _009_ VGND VGND VPWR VPWR net44 sky130_fd_sc_hd__dlygate4sd3_1
Xhold28 shiftreg_rx\[5\] VGND VGND VPWR VPWR net55 sky130_fd_sc_hd__dlygate4sd3_1
XTAP_TAPCELL_ROW_10_63 VGND VPWR sky130_fd_sc_hd__tapvpwrvgnd_1
XFILLER_19_72 VGND VGND VPWR VPWR sky130_fd_sc_hd__fill_1
X_148_ clknet_2_0__leaf_clkin _002_ net24 VGND VGND VPWR VPWR state\[2\] sky130_fd_sc_hd__dfrtp_4
XFILLER_10_85 VPWR VGND VPWR VGND sky130_ef_sc_hd__decap_12
Xoutput18 net18 VGND VGND VPWR VPWR data_out[5] sky130_fd_sc_hd__buf_2
X_079_ state\[1\] state\[2\] VGND VGND VPWR VPWR _059_ sky130_fd_sc_hd__nor2_2
XPHY_EDGE_ROW_5_Right_5 VGND VGND VPWR VPWR sky130_fd_sc_hd__decap_3
XFILLER_12_110 VGND VGND VPWR VPWR sky130_fd_sc_hd__decap_4
XFILLER_1_99 VGND VGND VPWR VPWR sky130_fd_sc_hd__fill_1
X_095_ datacounter\[0\] datacounter\[1\] datacounter\[2\] VGND VGND VPWR VPWR _070_
+ sky130_fd_sc_hd__o21ai_1
X_164_ clknet_2_3__leaf_clkin _020_ net25 VGND VGND VPWR VPWR shiftreg_tx\[6\] sky130_fd_sc_hd__dfrtp_1
Xhold29 shiftreg_rx\[0\] VGND VGND VPWR VPWR net56 sky130_fd_sc_hd__dlygate4sd3_1
Xhold18 shiftreg_tx\[7\] VGND VGND VPWR VPWR net45 sky130_fd_sc_hd__dlygate4sd3_1
XTAP_TAPCELL_ROW_6_54 VGND VPWR sky130_fd_sc_hd__tapvpwrvgnd_1
XFILLER_10_97 VPWR VGND VPWR VGND sky130_ef_sc_hd__decap_12
X_147_ clknet_2_2__leaf_clkin _001_ net23 VGND VGND VPWR VPWR state\[1\] sky130_fd_sc_hd__dfrtp_2
X_078_ state\[1\] _052_ VGND VGND VPWR VPWR _058_ sky130_fd_sc_hd__or2_1
XFILLER_18_3 VPWR VGND VPWR VGND sky130_ef_sc_hd__decap_12
Xoutput19 net19 VGND VGND VPWR VPWR data_out[6] sky130_fd_sc_hd__buf_2
XTAP_TAPCELL_ROW_16_74 VGND VPWR sky130_fd_sc_hd__tapvpwrvgnd_1
XPHY_EDGE_ROW_11_Right_11 VGND VGND VPWR VPWR sky130_fd_sc_hd__decap_3
XFILLER_16_85 VPWR VGND VPWR VGND sky130_ef_sc_hd__decap_12
XPHY_EDGE_ROW_19_Left_39 VGND VGND VPWR VPWR sky130_fd_sc_hd__decap_3
XFILLER_4_33 VGND VGND VPWR VPWR sky130_fd_sc_hd__fill_1
X_094_ datacounter\[1\] _068_ _069_ _067_ net12 VGND VGND VPWR VPWR _004_ sky130_fd_sc_hd__a221o_1
X_163_ clknet_2_2__leaf_clkin _019_ net27 VGND VGND VPWR VPWR shiftreg_tx\[5\] sky130_fd_sc_hd__dfrtp_1
Xhold19 shiftreg_tx\[2\] VGND VGND VPWR VPWR net46 sky130_fd_sc_hd__dlygate4sd3_1
XFILLER_19_85 VPWR VGND VPWR VGND sky130_ef_sc_hd__decap_12
XPHY_EDGE_ROW_7_Left_27 VGND VGND VPWR VPWR sky130_fd_sc_hd__decap_3
XFILLER_19_41 VGND VGND VPWR VPWR sky130_fd_sc_hd__decap_4
XTAP_TAPCELL_ROW_6_55 VGND VPWR sky130_fd_sc_hd__tapvpwrvgnd_1
X_077_ state\[0\] _057_ net12 VGND VGND VPWR VPWR _002_ sky130_fd_sc_hd__o21ba_1
X_146_ clknet_2_2__leaf_clkin _000_ net23 VGND VGND VPWR VPWR state\[0\] sky130_fd_sc_hd__dfstp_1
XFILLER_16_109 VGND VGND VPWR VPWR sky130_fd_sc_hd__decap_6
X_129_ net22 shiftreg_rx\[0\] VGND VGND VPWR VPWR _045_ sky130_fd_sc_hd__and2_1
XTAP_TAPCELL_ROW_16_75 VGND VPWR sky130_fd_sc_hd__tapvpwrvgnd_1
Xclkbuf_2_2__f_clkin clknet_0_clkin VGND VGND VPWR VPWR clknet_2_2__leaf_clkin sky130_fd_sc_hd__clkbuf_16
XFILLER_16_97 VPWR VGND VPWR VGND sky130_ef_sc_hd__decap_12
XFILLER_4_23 VGND VGND VPWR VPWR sky130_fd_sc_hd__decap_4
Xfanout22 net23 VGND VGND VPWR VPWR net22 sky130_fd_sc_hd__buf_2
XFILLER_13_54 VGND VGND VPWR VPWR sky130_fd_sc_hd__fill_2
X_093_ datacounter\[0\] datacounter\[1\] state\[2\] VGND VGND VPWR VPWR _069_ sky130_fd_sc_hd__o21ai_1
X_162_ clknet_2_2__leaf_clkin _018_ net27 VGND VGND VPWR VPWR shiftreg_tx\[4\] sky130_fd_sc_hd__dfrtp_1
Xinput1 data_in[0] VGND VGND VPWR VPWR net1 sky130_fd_sc_hd__clkbuf_1
XFILLER_19_97 VPWR VGND VPWR VGND sky130_ef_sc_hd__decap_12
X_076_ _054_ _055_ _056_ VGND VGND VPWR VPWR _057_ sky130_fd_sc_hd__o21ba_1
X_145_ clknet_2_3__leaf_clkin _005_ net26 VGND VGND VPWR VPWR datacounter\[2\] sky130_fd_sc_hd__dfstp_1
X_128_ _044_ net56 _043_ VGND VGND VPWR VPWR _022_ sky130_fd_sc_hd__mux2_1
XPHY_EDGE_ROW_10_Left_30 VGND VGND VPWR VPWR sky130_fd_sc_hd__decap_3
XPHY_EDGE_ROW_9_Right_9 VGND VGND VPWR VPWR sky130_fd_sc_hd__decap_3
Xfanout23 net27 VGND VGND VPWR VPWR net23 sky130_fd_sc_hd__clkbuf_4
X_161_ clknet_2_2__leaf_clkin _017_ net27 VGND VGND VPWR VPWR shiftreg_tx\[3\] sky130_fd_sc_hd__dfrtp_1
X_092_ net25 datacounter\[0\] _066_ VGND VGND VPWR VPWR _068_ sky130_fd_sc_hd__a21o_1
XFILLER_10_23 VGND VGND VPWR VPWR sky130_fd_sc_hd__decap_4
Xinput2 data_in[1] VGND VGND VPWR VPWR net2 sky130_fd_sc_hd__clkbuf_1
XFILLER_19_76 VGND VGND VPWR VPWR sky130_fd_sc_hd__decap_4
X_075_ net25 state\[2\] VGND VGND VPWR VPWR _056_ sky130_fd_sc_hd__nand2_1
X_144_ clknet_2_3__leaf_clkin _004_ net26 VGND VGND VPWR VPWR datacounter\[1\] sky130_fd_sc_hd__dfstp_1
XFILLER_7_57 VPWR VGND VPWR VGND sky130_ef_sc_hd__decap_12
X_127_ net22 net11 VGND VGND VPWR VPWR _044_ sky130_fd_sc_hd__and2_1
XFILLER_12_114 VGND VGND VPWR VPWR sky130_fd_sc_hd__fill_1
Xfanout24 net26 VGND VGND VPWR VPWR net24 sky130_fd_sc_hd__buf_2
XFILLER_1_113 VGND VGND VPWR VPWR sky130_fd_sc_hd__fill_2
XFILLER_1_15 VGND VGND VPWR VPWR sky130_fd_sc_hd__fill_2
X_091_ datacounter\[0\] _066_ _067_ _064_ net12 VGND VGND VPWR VPWR _003_ sky130_fd_sc_hd__a221o_1
X_160_ clknet_2_2__leaf_clkin _016_ net23 VGND VGND VPWR VPWR shiftreg_tx\[2\] sky130_fd_sc_hd__dfrtp_1
Xinput3 data_in[2] VGND VGND VPWR VPWR net3 sky130_fd_sc_hd__clkbuf_1
XPHY_EDGE_ROW_18_Right_18 VGND VGND VPWR VPWR sky130_fd_sc_hd__decap_3
XFILLER_19_109 VGND VGND VPWR VPWR sky130_fd_sc_hd__decap_3
XFILLER_10_13 VGND VGND VPWR VPWR sky130_fd_sc_hd__fill_1
X_074_ datacounter\[0\] datacounter\[1\] datacounter\[2\] VGND VGND VPWR VPWR _055_
+ sky130_fd_sc_hd__or3_1
X_143_ clknet_2_3__leaf_clkin _003_ net26 VGND VGND VPWR VPWR datacounter\[0\] sky130_fd_sc_hd__dfstp_1
XFILLER_7_69 VGND VGND VPWR VPWR sky130_fd_sc_hd__fill_1
X_126_ net12 _065_ _031_ _042_ VGND VGND VPWR VPWR _043_ sky130_fd_sc_hd__or4_4
XFILLER_16_23 VGND VGND VPWR VPWR sky130_fd_sc_hd__decap_4
XTAP_TAPCELL_ROW_3_48 VGND VPWR sky130_fd_sc_hd__tapvpwrvgnd_1
XPHY_EDGE_ROW_0_Right_0 VGND VGND VPWR VPWR sky130_fd_sc_hd__decap_3
X_109_ net1 _059_ _032_ _033_ net29 VGND VGND VPWR VPWR _014_ sky130_fd_sc_hd__a32o_1
XFILLER_13_46 VGND VGND VPWR VPWR sky130_fd_sc_hd__decap_4
XTAP_TAPCELL_ROW_13_68 VGND VPWR sky130_fd_sc_hd__tapvpwrvgnd_1
XFILLER_13_57 VGND VGND VPWR VPWR sky130_fd_sc_hd__fill_1
Xfanout25 net26 VGND VGND VPWR VPWR net25 sky130_fd_sc_hd__buf_2
XFILLER_6_3 VPWR VGND VPWR VGND sky130_ef_sc_hd__decap_12
X_090_ _052_ _066_ VGND VGND VPWR VPWR _067_ sky130_fd_sc_hd__nor2_1
Xinput4 data_in[3] VGND VGND VPWR VPWR net4 sky130_fd_sc_hd__clkbuf_1
X_142_ _051_ net28 _043_ VGND VGND VPWR VPWR _029_ sky130_fd_sc_hd__mux2_1
X_073_ net10 rx VGND VGND VPWR VPWR _054_ sky130_fd_sc_hd__nand2b_2
XFILLER_7_15 VGND VGND VPWR VPWR sky130_fd_sc_hd__decap_4
X_125_ _053_ net10 _056_ VGND VGND VPWR VPWR _042_ sky130_fd_sc_hd__a21oi_1
XFILLER_15_113 VGND VGND VPWR VPWR sky130_fd_sc_hd__fill_2
XTAP_TAPCELL_ROW_3_49 VGND VPWR sky130_fd_sc_hd__tapvpwrvgnd_1
X_108_ net25 _054_ _060_ _031_ net12 VGND VGND VPWR VPWR _033_ sky130_fd_sc_hd__a311o_4
XPHY_EDGE_ROW_14_Left_34 VGND VGND VPWR VPWR sky130_fd_sc_hd__decap_3
XFILLER_4_27 VGND VGND VPWR VPWR sky130_fd_sc_hd__fill_1
Xfanout26 net27 VGND VGND VPWR VPWR net26 sky130_fd_sc_hd__buf_2
XTAP_TAPCELL_ROW_13_69 VGND VPWR sky130_fd_sc_hd__tapvpwrvgnd_1
Xinput5 data_in[4] VGND VGND VPWR VPWR net5 sky130_fd_sc_hd__clkbuf_1
XFILLER_10_37 VPWR VGND VPWR VGND sky130_ef_sc_hd__decap_12
XFILLER_19_68 VGND VGND VPWR VPWR sky130_fd_sc_hd__decap_4
XPHY_EDGE_ROW_2_Left_22 VGND VGND VPWR VPWR sky130_fd_sc_hd__decap_3
X_141_ net24 shiftreg_rx\[6\] VGND VGND VPWR VPWR _051_ sky130_fd_sc_hd__and2_1
X_072_ rx VGND VGND VPWR VPWR _053_ sky130_fd_sc_hd__inv_2
X_124_ _041_ net45 _033_ VGND VGND VPWR VPWR _021_ sky130_fd_sc_hd__mux2_1
XFILLER_7_110 VGND VGND VPWR VPWR sky130_fd_sc_hd__fill_2
X_107_ net12 _031_ VGND VGND VPWR VPWR _032_ sky130_fd_sc_hd__nor2_1
XFILLER_4_113 VGND VGND VPWR VPWR sky130_fd_sc_hd__fill_2
XFILLER_17_90 VPWR VGND VPWR VGND sky130_ef_sc_hd__decap_12
Xfanout27 net9 VGND VGND VPWR VPWR net27 sky130_fd_sc_hd__clkbuf_2
XFILLER_14_91 VGND VGND VPWR VPWR sky130_fd_sc_hd__fill_1
XFILLER_10_27 VGND VGND VPWR VPWR sky130_fd_sc_hd__fill_1
XFILLER_10_49 VGND VGND VPWR VPWR sky130_fd_sc_hd__decap_3
Xinput6 data_in[5] VGND VGND VPWR VPWR net6 sky130_fd_sc_hd__clkbuf_1
X_140_ _050_ net52 _043_ VGND VGND VPWR VPWR _028_ sky130_fd_sc_hd__mux2_1
X_071_ net25 VGND VGND VPWR VPWR _052_ sky130_fd_sc_hd__inv_2
XPHY_EDGE_ROW_14_Right_14 VGND VGND VPWR VPWR sky130_fd_sc_hd__decap_3
XFILLER_2_94 VGND VGND VPWR VPWR sky130_fd_sc_hd__fill_1
XFILLER_2_83 VGND VGND VPWR VPWR sky130_fd_sc_hd__fill_1
X_123_ net8 _059_ _034_ shiftreg_tx\[6\] VGND VGND VPWR VPWR _041_ sky130_fd_sc_hd__a22o_1
X_106_ state\[0\] _060_ VGND VGND VPWR VPWR _031_ sky130_fd_sc_hd__nor2_1
XPHY_EDGE_ROW_4_Right_4 VGND VGND VPWR VPWR sky130_fd_sc_hd__decap_3
XFILLER_8_93 VGND VGND VPWR VPWR sky130_fd_sc_hd__fill_1
XFILLER_4_29 VGND VGND VPWR VPWR sky130_fd_sc_hd__decap_4
XTAP_TAPCELL_ROW_4_50 VGND VPWR sky130_fd_sc_hd__tapvpwrvgnd_1
XTAP_TAPCELL_ROW_14_70 VGND VPWR sky130_fd_sc_hd__tapvpwrvgnd_1
Xinput7 data_in[6] VGND VGND VPWR VPWR net7 sky130_fd_sc_hd__clkbuf_1
XFILLER_19_15 VPWR VGND VPWR VGND sky130_ef_sc_hd__decap_12
XFILLER_19_37 VGND VGND VPWR VPWR sky130_fd_sc_hd__fill_1
XFILLER_19_48 VGND VGND VPWR VPWR sky130_fd_sc_hd__decap_8
XFILLER_18_113 VGND VGND VPWR VPWR sky130_fd_sc_hd__fill_2
XFILLER_7_29 VGND VGND VPWR VPWR sky130_fd_sc_hd__fill_1
X_122_ _040_ net51 _033_ VGND VGND VPWR VPWR _020_ sky130_fd_sc_hd__mux2_1
Xinput10 sclk VGND VGND VPWR VPWR net10 sky130_fd_sc_hd__buf_1
XFILLER_16_27 VGND VGND VPWR VPWR sky130_fd_sc_hd__fill_1
XFILLER_16_49 VGND VGND VPWR VPWR sky130_fd_sc_hd__decap_4
X_105_ net28 net30 _062_ VGND VGND VPWR VPWR _013_ sky130_fd_sc_hd__mux2_1
XFILLER_8_83 VGND VGND VPWR VPWR sky130_fd_sc_hd__fill_1
XTAP_TAPCELL_ROW_4_51 VGND VPWR sky130_fd_sc_hd__tapvpwrvgnd_1
XPHY_EDGE_ROW_18_Left_38 VGND VGND VPWR VPWR sky130_fd_sc_hd__decap_3
XTAP_TAPCELL_ROW_14_71 VGND VPWR sky130_fd_sc_hd__tapvpwrvgnd_1
Xinput8 data_in[7] VGND VGND VPWR VPWR net8 sky130_fd_sc_hd__clkbuf_1
XFILLER_19_27 VGND VGND VPWR VPWR sky130_fd_sc_hd__fill_1
XPHY_EDGE_ROW_6_Left_26 VGND VGND VPWR VPWR sky130_fd_sc_hd__decap_3
XFILLER_7_19 VGND VGND VPWR VPWR sky130_fd_sc_hd__fill_1
X_121_ net7 _059_ _034_ shiftreg_tx\[5\] VGND VGND VPWR VPWR _040_ sky130_fd_sc_hd__a22o_1
Xinput11 sdi VGND VGND VPWR VPWR net11 sky130_fd_sc_hd__clkbuf_1
X_104_ shiftreg_rx\[6\] net35 _062_ VGND VGND VPWR VPWR _012_ sky130_fd_sc_hd__mux2_1
XFILLER_7_113 VGND VGND VPWR VPWR sky130_fd_sc_hd__fill_2
XFILLER_14_6 VGND VGND VPWR VPWR sky130_fd_sc_hd__decap_3
Xinput9 reset VGND VGND VPWR VPWR net9 sky130_fd_sc_hd__clkbuf_1
XFILLER_14_50 VGND VGND VPWR VPWR sky130_fd_sc_hd__decap_6
XPHY_EDGE_ROW_10_Right_10 VGND VGND VPWR VPWR sky130_fd_sc_hd__decap_3
X_120_ _039_ net49 _033_ VGND VGND VPWR VPWR _019_ sky130_fd_sc_hd__mux2_1
Xinput12 slave_select_in VGND VGND VPWR VPWR net12 sky130_fd_sc_hd__buf_2
X_103_ shiftreg_rx\[5\] net31 _062_ VGND VGND VPWR VPWR _011_ sky130_fd_sc_hd__mux2_1
XFILLER_8_85 VGND VGND VPWR VPWR sky130_fd_sc_hd__decap_8
XPHY_EDGE_ROW_8_Right_8 VGND VGND VPWR VPWR sky130_fd_sc_hd__decap_3
Xhold1 shiftreg_rx\[7\] VGND VGND VPWR VPWR net28 sky130_fd_sc_hd__dlygate4sd3_1
XFILLER_18_105 VGND VGND VPWR VPWR sky130_fd_sc_hd__decap_8
XFILLER_15_108 VGND VGND VPWR VPWR sky130_fd_sc_hd__decap_4
XFILLER_2_3 VGND VGND VPWR VPWR sky130_fd_sc_hd__decap_8
X_102_ shiftreg_rx\[4\] net33 _062_ VGND VGND VPWR VPWR _010_ sky130_fd_sc_hd__mux2_1
Xhold2 shiftreg_tx\[0\] VGND VGND VPWR VPWR net29 sky130_fd_sc_hd__dlygate4sd3_1
XFILLER_5_65 VGND VGND VPWR VPWR sky130_fd_sc_hd__decap_3
XTAP_TAPCELL_ROW_1_44 VGND VPWR sky130_fd_sc_hd__tapvpwrvgnd_1
XFILLER_2_11 VGND VGND VPWR VPWR sky130_fd_sc_hd__fill_1
Xclkbuf_2_1__f_clkin clknet_0_clkin VGND VGND VPWR VPWR clknet_2_1__leaf_clkin sky130_fd_sc_hd__clkbuf_16
XTAP_TAPCELL_ROW_11_64 VGND VPWR sky130_fd_sc_hd__tapvpwrvgnd_1
X_101_ shiftreg_rx\[3\] net43 _062_ VGND VGND VPWR VPWR _009_ sky130_fd_sc_hd__mux2_1
XFILLER_8_43 VGND VGND VPWR VPWR sky130_fd_sc_hd__decap_6
Xhold3 net20 VGND VGND VPWR VPWR net30 sky130_fd_sc_hd__dlygate4sd3_1
XFILLER_12_6 VGND VGND VPWR VPWR sky130_fd_sc_hd__fill_1
XFILLER_17_30 VGND VGND VPWR VPWR sky130_fd_sc_hd__decap_6
XTAP_TAPCELL_ROW_1_45 VGND VPWR sky130_fd_sc_hd__tapvpwrvgnd_1
XTAP_TAPCELL_ROW_11_65 VGND VPWR sky130_fd_sc_hd__tapvpwrvgnd_1
X_100_ shiftreg_rx\[2\] net37 _062_ VGND VGND VPWR VPWR _008_ sky130_fd_sc_hd__mux2_1
XFILLER_11_113 VGND VGND VPWR VPWR sky130_fd_sc_hd__fill_2
Xhold4 net18 VGND VGND VPWR VPWR net31 sky130_fd_sc_hd__dlygate4sd3_1
XPHY_EDGE_ROW_13_Left_33 VGND VGND VPWR VPWR sky130_fd_sc_hd__decap_3
XPHY_EDGE_ROW_17_Right_17 VGND VGND VPWR VPWR sky130_fd_sc_hd__decap_3
XPHY_EDGE_ROW_1_Left_21 VGND VGND VPWR VPWR sky130_fd_sc_hd__decap_3
XFILLER_11_55 VGND VGND VPWR VPWR sky130_fd_sc_hd__fill_1
XTAP_TAPCELL_ROW_7_56 VGND VPWR sky130_fd_sc_hd__tapvpwrvgnd_1
XFILLER_0_3 VPWR VGND VPWR VGND sky130_ef_sc_hd__decap_12
X_159_ clknet_2_2__leaf_clkin _015_ net23 VGND VGND VPWR VPWR shiftreg_tx\[1\] sky130_fd_sc_hd__dfrtp_1
XTAP_TAPCELL_ROW_17_76 VGND VPWR sky130_fd_sc_hd__tapvpwrvgnd_1
XFILLER_3_110 VGND VGND VPWR VPWR sky130_fd_sc_hd__fill_2
Xhold5 _011_ VGND VGND VPWR VPWR net32 sky130_fd_sc_hd__dlygate4sd3_1
XFILLER_0_113 VGND VGND VPWR VPWR sky130_fd_sc_hd__fill_2
XFILLER_5_24 VGND VGND VPWR VPWR sky130_fd_sc_hd__decap_3
XTAP_TAPCELL_ROW_7_57 VGND VPWR sky130_fd_sc_hd__tapvpwrvgnd_1
X_158_ clknet_2_2__leaf_clkin _014_ net23 VGND VGND VPWR VPWR shiftreg_tx\[0\] sky130_fd_sc_hd__dfrtp_1
X_089_ net25 _054_ _059_ _065_ VGND VGND VPWR VPWR _066_ sky130_fd_sc_hd__a211o_1
XTAP_TAPCELL_ROW_17_77 VGND VPWR sky130_fd_sc_hd__tapvpwrvgnd_1
Xhold6 net17 VGND VGND VPWR VPWR net33 sky130_fd_sc_hd__dlygate4sd3_1
XPHY_EDGE_ROW_3_Right_3 VGND VGND VPWR VPWR sky130_fd_sc_hd__decap_3
XFILLER_0_103 VGND VGND VPWR VPWR sky130_fd_sc_hd__fill_1
XFILLER_17_110 VGND VGND VPWR VPWR sky130_fd_sc_hd__fill_2
X_157_ clknet_2_1__leaf_clkin _013_ net26 VGND VGND VPWR VPWR net20 sky130_fd_sc_hd__dfrtp_1
X_088_ state\[2\] state\[0\] net25 VGND VGND VPWR VPWR _065_ sky130_fd_sc_hd__nor3b_1
XFILLER_19_3 VPWR VGND VPWR VGND sky130_ef_sc_hd__decap_12
Xhold7 _010_ VGND VGND VPWR VPWR net34 sky130_fd_sc_hd__dlygate4sd3_1
XFILLER_10_7 VGND VGND VPWR VPWR sky130_fd_sc_hd__decap_6
XPHY_EDGE_ROW_13_Right_13 VGND VGND VPWR VPWR sky130_fd_sc_hd__decap_3
XPHY_EDGE_ROW_17_Left_37 VGND VGND VPWR VPWR sky130_fd_sc_hd__decap_3
XFILLER_2_49 VGND VGND VPWR VPWR sky130_fd_sc_hd__fill_2
X_173_ clknet_2_1__leaf_clkin _029_ net26 VGND VGND VPWR VPWR shiftreg_rx\[7\] sky130_fd_sc_hd__dfrtp_1
XFILLER_14_114 VGND VGND VPWR VPWR sky130_fd_sc_hd__fill_1
XPHY_EDGE_ROW_5_Left_25 VGND VGND VPWR VPWR sky130_fd_sc_hd__decap_3
X_156_ clknet_2_1__leaf_clkin net36 net24 VGND VGND VPWR VPWR net19 sky130_fd_sc_hd__dfrtp_1
X_087_ state\[2\] datacounter\[0\] VGND VGND VPWR VPWR _064_ sky130_fd_sc_hd__nand2_1
XFILLER_3_113 VGND VGND VPWR VPWR sky130_fd_sc_hd__fill_2
Xhold8 net19 VGND VGND VPWR VPWR net35 sky130_fd_sc_hd__dlygate4sd3_1
XFILLER_17_57 VGND VGND VPWR VPWR sky130_fd_sc_hd__decap_6
X_139_ net24 shiftreg_rx\[5\] VGND VGND VPWR VPWR _050_ sky130_fd_sc_hd__and2_1
XFILLER_14_25 VGND VGND VPWR VPWR sky130_fd_sc_hd__decap_3
X_172_ clknet_2_1__leaf_clkin _028_ net26 VGND VGND VPWR VPWR shiftreg_rx\[6\] sky130_fd_sc_hd__dfrtp_1
X_155_ clknet_2_1__leaf_clkin net32 net24 VGND VGND VPWR VPWR net18 sky130_fd_sc_hd__dfrtp_1
XFILLER_8_49 VGND VGND VPWR VPWR sky130_fd_sc_hd__fill_1
X_086_ state\[2\] _054_ shiftreg_tx\[7\] net25 VGND VGND VPWR VPWR net21 sky130_fd_sc_hd__o211a_1
Xhold9 _012_ VGND VGND VPWR VPWR net36 sky130_fd_sc_hd__dlygate4sd3_1
X_138_ _049_ net55 _043_ VGND VGND VPWR VPWR _027_ sky130_fd_sc_hd__mux2_1
XFILLER_0_72 VGND VGND VPWR VPWR sky130_fd_sc_hd__decap_3
XFILLER_0_50 VGND VGND VPWR VPWR sky130_fd_sc_hd__fill_2
XPHY_EDGE_ROW_7_Right_7 VGND VGND VPWR VPWR sky130_fd_sc_hd__decap_3
XFILLER_2_29 VGND VGND VPWR VPWR sky130_fd_sc_hd__fill_2
XFILLER_17_102 VGND VGND VPWR VPWR sky130_fd_sc_hd__decap_8
XFILLER_17_113 VGND VGND VPWR VPWR sky130_fd_sc_hd__fill_2
X_171_ clknet_2_1__leaf_clkin _027_ net24 VGND VGND VPWR VPWR shiftreg_rx\[5\] sky130_fd_sc_hd__dfrtp_1
X_154_ clknet_2_0__leaf_clkin net34 net24 VGND VGND VPWR VPWR net17 sky130_fd_sc_hd__dfrtp_1
X_085_ _061_ _062_ _063_ VGND VGND VPWR VPWR _001_ sky130_fd_sc_hd__o21ai_1
X_137_ net24 shiftreg_rx\[4\] VGND VGND VPWR VPWR _049_ sky130_fd_sc_hd__and2_1
XFILLER_17_3 VGND VGND VPWR VPWR sky130_fd_sc_hd__decap_6
XFILLER_14_38 VPWR VGND VPWR VGND sky130_ef_sc_hd__decap_12
X_170_ clknet_2_0__leaf_clkin _026_ net24 VGND VGND VPWR VPWR shiftreg_rx\[4\] sky130_fd_sc_hd__dfrtp_1
XFILLER_14_106 VGND VGND VPWR VPWR sky130_fd_sc_hd__decap_8
X_153_ clknet_2_0__leaf_clkin net44 net23 VGND VGND VPWR VPWR net16 sky130_fd_sc_hd__dfrtp_1
X_084_ net12 _054_ _055_ _056_ VGND VGND VPWR VPWR _063_ sky130_fd_sc_hd__or4_1
XPHY_EDGE_ROW_9_Left_29 VGND VGND VPWR VPWR sky130_fd_sc_hd__decap_3
X_136_ _048_ net54 _043_ VGND VGND VPWR VPWR _026_ sky130_fd_sc_hd__mux2_1
X_119_ net6 _059_ _034_ shiftreg_tx\[4\] VGND VGND VPWR VPWR _039_ sky130_fd_sc_hd__a22o_1
XFILLER_9_6 VGND VGND VPWR VPWR sky130_fd_sc_hd__fill_1
XFILLER_7_3 VPWR VGND VPWR VGND sky130_ef_sc_hd__decap_12
XFILLER_9_100 VGND VGND VPWR VPWR sky130_fd_sc_hd__fill_1
X_152_ clknet_2_0__leaf_clkin net38 net22 VGND VGND VPWR VPWR net15 sky130_fd_sc_hd__dfrtp_1
X_083_ net12 state\[1\] VGND VGND VPWR VPWR _062_ sky130_fd_sc_hd__nand2b_4
X_135_ net22 shiftreg_rx\[3\] VGND VGND VPWR VPWR _048_ sky130_fd_sc_hd__and2_1
XFILLER_0_97 VGND VGND VPWR VPWR sky130_fd_sc_hd__fill_2
XFILLER_9_84 VPWR VGND VPWR VGND sky130_ef_sc_hd__decap_12
XTAP_TAPCELL_ROW_5_52 VGND VPWR sky130_fd_sc_hd__tapvpwrvgnd_1
X_118_ _038_ net50 _033_ VGND VGND VPWR VPWR _018_ sky130_fd_sc_hd__mux2_1
XFILLER_18_93 VPWR VGND VPWR VGND sky130_ef_sc_hd__decap_12
XPHY_EDGE_ROW_12_Left_32 VGND VGND VPWR VPWR sky130_fd_sc_hd__decap_3
XFILLER_14_29 VGND VGND VPWR VPWR sky130_fd_sc_hd__fill_2
XFILLER_6_85 VGND VGND VPWR VPWR sky130_fd_sc_hd__fill_1
XTAP_TAPCELL_ROW_15_72 VGND VPWR sky130_fd_sc_hd__tapvpwrvgnd_1
X_151_ clknet_2_0__leaf_clkin net40 net22 VGND VGND VPWR VPWR net14 sky130_fd_sc_hd__dfrtp_1
XPHY_EDGE_ROW_0_Left_20 VGND VGND VPWR VPWR sky130_fd_sc_hd__decap_3
X_082_ _058_ _060_ _061_ net12 VGND VGND VPWR VPWR _000_ sky130_fd_sc_hd__a31o_1
X_134_ _047_ net53 _043_ VGND VGND VPWR VPWR _025_ sky130_fd_sc_hd__mux2_1
XFILLER_9_96 VGND VGND VPWR VPWR sky130_fd_sc_hd__decap_4
XTAP_TAPCELL_ROW_5_53 VGND VPWR sky130_fd_sc_hd__tapvpwrvgnd_1
X_117_ net5 _059_ _034_ shiftreg_tx\[3\] VGND VGND VPWR VPWR _038_ sky130_fd_sc_hd__a22o_1
Xclkbuf_2_0__f_clkin clknet_0_clkin VGND VGND VPWR VPWR clknet_2_0__leaf_clkin sky130_fd_sc_hd__clkbuf_16
XTAP_TAPCELL_ROW_15_73 VGND VPWR sky130_fd_sc_hd__tapvpwrvgnd_1
XFILLER_15_84 VGND VGND VPWR VPWR sky130_fd_sc_hd__decap_3
XFILLER_9_113 VGND VGND VPWR VPWR sky130_fd_sc_hd__fill_2
XFILLER_3_98 VGND VGND VPWR VPWR sky130_fd_sc_hd__decap_3
XFILLER_3_87 VGND VGND VPWR VPWR sky130_fd_sc_hd__fill_2
XFILLER_3_54 VGND VGND VPWR VPWR sky130_fd_sc_hd__fill_2
X_150_ clknet_2_2__leaf_clkin net42 net22 VGND VGND VPWR VPWR net13 sky130_fd_sc_hd__dfrtp_1
X_081_ net25 _054_ VGND VGND VPWR VPWR _061_ sky130_fd_sc_hd__nand2_1
XPHY_EDGE_ROW_16_Right_16 VGND VGND VPWR VPWR sky130_fd_sc_hd__decap_3
X_133_ net22 shiftreg_rx\[2\] VGND VGND VPWR VPWR _047_ sky130_fd_sc_hd__and2_1
X_116_ _037_ net48 _033_ VGND VGND VPWR VPWR _017_ sky130_fd_sc_hd__mux2_1
XPHY_EDGE_ROW_2_Right_2 VGND VGND VPWR VPWR sky130_fd_sc_hd__decap_3
XFILLER_15_52 VGND VGND VPWR VPWR sky130_fd_sc_hd__decap_4
X_080_ state\[1\] state\[2\] VGND VGND VPWR VPWR _060_ sky130_fd_sc_hd__or2_1
X_132_ _046_ net58 _043_ VGND VGND VPWR VPWR _024_ sky130_fd_sc_hd__mux2_1
XFILLER_9_43 VGND VGND VPWR VPWR sky130_fd_sc_hd__fill_1
X_115_ net4 _059_ _034_ shiftreg_tx\[2\] VGND VGND VPWR VPWR _037_ sky130_fd_sc_hd__a22o_1
XPHY_EDGE_ROW_16_Left_36 VGND VGND VPWR VPWR sky130_fd_sc_hd__decap_3
XFILLER_15_31 VGND VGND VPWR VPWR sky130_fd_sc_hd__decap_6
XFILLER_15_64 VPWR VGND VPWR VGND sky130_ef_sc_hd__decap_12
.ends
