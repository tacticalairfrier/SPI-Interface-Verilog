* NGSPICE file created from Master.ext - technology: sky130A

* Black-box entry subcircuit for sky130_fd_sc_hd__fill_2 abstract view
.subckt sky130_fd_sc_hd__fill_2 VGND VNB VPB VPWR
.ends

* Black-box entry subcircuit for sky130_fd_sc_hd__decap_3 abstract view
.subckt sky130_fd_sc_hd__decap_3 VGND VNB VPB VPWR
.ends

* Black-box entry subcircuit for sky130_fd_sc_hd__fill_1 abstract view
.subckt sky130_fd_sc_hd__fill_1 VGND VNB VPB VPWR
.ends

* Black-box entry subcircuit for sky130_fd_sc_hd__dfrtp_1 abstract view
.subckt sky130_fd_sc_hd__dfrtp_1 CLK D RESET_B VGND VNB VPB VPWR Q
.ends

* Black-box entry subcircuit for sky130_fd_sc_hd__mux2_1 abstract view
.subckt sky130_fd_sc_hd__mux2_1 A0 A1 S VGND VNB VPB VPWR X
.ends

* Black-box entry subcircuit for sky130_fd_sc_hd__tapvpwrvgnd_1 abstract view
.subckt sky130_fd_sc_hd__tapvpwrvgnd_1 VGND VPWR
.ends

* Black-box entry subcircuit for sky130_fd_sc_hd__nand2_1 abstract view
.subckt sky130_fd_sc_hd__nand2_1 A B VGND VNB VPB VPWR Y
.ends

* Black-box entry subcircuit for sky130_fd_sc_hd__dlygate4sd3_1 abstract view
.subckt sky130_fd_sc_hd__dlygate4sd3_1 A VGND VNB VPB VPWR X
.ends

* Black-box entry subcircuit for sky130_fd_sc_hd__decap_8 abstract view
.subckt sky130_fd_sc_hd__decap_8 VGND VNB VPB VPWR
.ends

* Black-box entry subcircuit for sky130_fd_sc_hd__buf_2 abstract view
.subckt sky130_fd_sc_hd__buf_2 A VGND VNB VPB VPWR X
.ends

* Black-box entry subcircuit for sky130_fd_sc_hd__clkbuf_16 abstract view
.subckt sky130_fd_sc_hd__clkbuf_16 A VGND VNB VPB VPWR X
.ends

* Black-box entry subcircuit for sky130_fd_sc_hd__or2_1 abstract view
.subckt sky130_fd_sc_hd__or2_1 A B VGND VNB VPB VPWR X
.ends

* Black-box entry subcircuit for sky130_fd_sc_hd__decap_4 abstract view
.subckt sky130_fd_sc_hd__decap_4 VGND VNB VPB VPWR
.ends

* Black-box entry subcircuit for sky130_ef_sc_hd__decap_12 abstract view
.subckt sky130_ef_sc_hd__decap_12 VPWR VGND VPB VNB
.ends

* Black-box entry subcircuit for sky130_fd_sc_hd__decap_6 abstract view
.subckt sky130_fd_sc_hd__decap_6 VGND VNB VPB VPWR
.ends

* Black-box entry subcircuit for sky130_fd_sc_hd__nor2_1 abstract view
.subckt sky130_fd_sc_hd__nor2_1 A B VGND VNB VPB VPWR Y
.ends

* Black-box entry subcircuit for sky130_fd_sc_hd__o21a_1 abstract view
.subckt sky130_fd_sc_hd__o21a_1 A1 A2 B1 VGND VNB VPB VPWR X
.ends

* Black-box entry subcircuit for sky130_fd_sc_hd__clkbuf_8 abstract view
.subckt sky130_fd_sc_hd__clkbuf_8 A VGND VNB VPB VPWR X
.ends

* Black-box entry subcircuit for sky130_fd_sc_hd__clkinv_2 abstract view
.subckt sky130_fd_sc_hd__clkinv_2 A VGND VNB VPB VPWR Y
.ends

* Black-box entry subcircuit for sky130_fd_sc_hd__and2_1 abstract view
.subckt sky130_fd_sc_hd__and2_1 A B VGND VNB VPB VPWR X
.ends

* Black-box entry subcircuit for sky130_fd_sc_hd__clkinv_4 abstract view
.subckt sky130_fd_sc_hd__clkinv_4 A VGND VNB VPB VPWR Y
.ends

* Black-box entry subcircuit for sky130_fd_sc_hd__xor2_1 abstract view
.subckt sky130_fd_sc_hd__xor2_1 A B VGND VNB VPB VPWR X
.ends

* Black-box entry subcircuit for sky130_fd_sc_hd__dfxtp_1 abstract view
.subckt sky130_fd_sc_hd__dfxtp_1 CLK D VGND VNB VPB VPWR Q
.ends

* Black-box entry subcircuit for sky130_fd_sc_hd__a32o_1 abstract view
.subckt sky130_fd_sc_hd__a32o_1 A1 A2 A3 B1 B2 VGND VNB VPB VPWR X
.ends

* Black-box entry subcircuit for sky130_fd_sc_hd__or4_1 abstract view
.subckt sky130_fd_sc_hd__or4_1 A B C D VGND VNB VPB VPWR X
.ends

* Black-box entry subcircuit for sky130_fd_sc_hd__a2bb2o_1 abstract view
.subckt sky130_fd_sc_hd__a2bb2o_1 A1_N A2_N B1 B2 VGND VNB VPB VPWR X
.ends

* Black-box entry subcircuit for sky130_fd_sc_hd__nand2_4 abstract view
.subckt sky130_fd_sc_hd__nand2_4 A B VGND VNB VPB VPWR Y
.ends

* Black-box entry subcircuit for sky130_fd_sc_hd__clkbuf_1 abstract view
.subckt sky130_fd_sc_hd__clkbuf_1 A VGND VNB VPB VPWR X
.ends

* Black-box entry subcircuit for sky130_fd_sc_hd__clkbuf_2 abstract view
.subckt sky130_fd_sc_hd__clkbuf_2 A VGND VNB VPB VPWR X
.ends

* Black-box entry subcircuit for sky130_fd_sc_hd__a41o_1 abstract view
.subckt sky130_fd_sc_hd__a41o_1 A1 A2 A3 A4 B1 VGND VNB VPB VPWR X
.ends

* Black-box entry subcircuit for sky130_fd_sc_hd__o31a_1 abstract view
.subckt sky130_fd_sc_hd__o31a_1 A1 A2 A3 B1 VGND VNB VPB VPWR X
.ends

* Black-box entry subcircuit for sky130_fd_sc_hd__nand3_1 abstract view
.subckt sky130_fd_sc_hd__nand3_1 A B C VGND VNB VPB VPWR Y
.ends

* Black-box entry subcircuit for sky130_fd_sc_hd__or4b_1 abstract view
.subckt sky130_fd_sc_hd__or4b_1 A B C D_N VGND VNB VPB VPWR X
.ends

* Black-box entry subcircuit for sky130_fd_sc_hd__nand3b_1 abstract view
.subckt sky130_fd_sc_hd__nand3b_1 A_N B C VGND VNB VPB VPWR Y
.ends

* Black-box entry subcircuit for sky130_fd_sc_hd__clkbuf_4 abstract view
.subckt sky130_fd_sc_hd__clkbuf_4 A VGND VNB VPB VPWR X
.ends

* Black-box entry subcircuit for sky130_fd_sc_hd__or3b_1 abstract view
.subckt sky130_fd_sc_hd__or3b_1 A B C_N VGND VNB VPB VPWR X
.ends

* Black-box entry subcircuit for sky130_fd_sc_hd__o21ai_1 abstract view
.subckt sky130_fd_sc_hd__o21ai_1 A1 A2 B1 VGND VNB VPB VPWR Y
.ends

* Black-box entry subcircuit for sky130_fd_sc_hd__o21ba_1 abstract view
.subckt sky130_fd_sc_hd__o21ba_1 A1 A2 B1_N VGND VNB VPB VPWR X
.ends

* Black-box entry subcircuit for sky130_fd_sc_hd__buf_1 abstract view
.subckt sky130_fd_sc_hd__buf_1 A VGND VNB VPB VPWR X
.ends

* Black-box entry subcircuit for sky130_fd_sc_hd__dfrtp_2 abstract view
.subckt sky130_fd_sc_hd__dfrtp_2 CLK D RESET_B VGND VNB VPB VPWR Q
.ends

* Black-box entry subcircuit for sky130_fd_sc_hd__dfstp_1 abstract view
.subckt sky130_fd_sc_hd__dfstp_1 CLK D SET_B VGND VNB VPB VPWR Q
.ends

* Black-box entry subcircuit for sky130_fd_sc_hd__o221a_1 abstract view
.subckt sky130_fd_sc_hd__o221a_1 A1 A2 B1 B2 C1 VGND VNB VPB VPWR X
.ends

* Black-box entry subcircuit for sky130_fd_sc_hd__and3_1 abstract view
.subckt sky130_fd_sc_hd__and3_1 A B C VGND VNB VPB VPWR X
.ends

* Black-box entry subcircuit for sky130_fd_sc_hd__o21ba_2 abstract view
.subckt sky130_fd_sc_hd__o21ba_2 A1 A2 B1_N VGND VNB VPB VPWR X
.ends

* Black-box entry subcircuit for sky130_fd_sc_hd__o22a_1 abstract view
.subckt sky130_fd_sc_hd__o22a_1 A1 A2 B1 B2 VGND VNB VPB VPWR X
.ends

* Black-box entry subcircuit for sky130_fd_sc_hd__a21o_1 abstract view
.subckt sky130_fd_sc_hd__a21o_1 A1 A2 B1 VGND VNB VPB VPWR X
.ends

* Black-box entry subcircuit for sky130_fd_sc_hd__a21bo_1 abstract view
.subckt sky130_fd_sc_hd__a21bo_1 A1 A2 B1_N VGND VNB VPB VPWR X
.ends

* Black-box entry subcircuit for sky130_fd_sc_hd__nor2_2 abstract view
.subckt sky130_fd_sc_hd__nor2_2 A B VGND VNB VPB VPWR Y
.ends

* Black-box entry subcircuit for sky130_fd_sc_hd__and3b_1 abstract view
.subckt sky130_fd_sc_hd__and3b_1 A_N B C VGND VNB VPB VPWR X
.ends

* Black-box entry subcircuit for sky130_fd_sc_hd__or3b_4 abstract view
.subckt sky130_fd_sc_hd__or3b_4 A B C_N VGND VNB VPB VPWR X
.ends

* Black-box entry subcircuit for sky130_fd_sc_hd__a21oi_1 abstract view
.subckt sky130_fd_sc_hd__a21oi_1 A1 A2 B1 VGND VNB VPB VPWR Y
.ends

.subckt Master VGND VPWR clkin data_in[0] data_in[1] data_in[2] data_in[3] data_in[4]
+ data_in[5] data_in[6] data_in[7] data_out[0] data_out[1] data_out[2] data_out[3]
+ data_out[4] data_out[5] data_out[6] data_out[7] miso mode[0] mode[1] mosi reset
+ sclk slave_select[0] slave_select[1] slave_select[2] slave_select[3] slave_select_in[0]
+ slave_select_in[1] tx_enable
XFILLER_3_34 VGND VGND VPWR VPWR sky130_fd_sc_hd__fill_2
XFILLER_3_23 VGND VGND VPWR VPWR sky130_fd_sc_hd__decap_3
XFILLER_10_103 VGND VGND VPWR VPWR sky130_fd_sc_hd__fill_1
X_200_ clknet_2_1__leaf_clkin _026_ net38 VGND VGND VPWR VPWR shiftreg\[7\] sky130_fd_sc_hd__dfrtp_1
X_131_ shiftreg_rx\[2\] net46 _040_ VGND VGND VPWR VPWR _013_ sky130_fd_sc_hd__mux2_1
XFILLER_9_33 VGND VGND VPWR VPWR sky130_fd_sc_hd__decap_3
XTAP_TAPCELL_ROW_5_56 VGND VPWR sky130_fd_sc_hd__tapvpwrvgnd_1
X_114_ counter_sclk\[1\] net77 VGND VGND VPWR VPWR _051_ sky130_fd_sc_hd__nand2_1
XTAP_TAPCELL_ROW_20_87 VGND VPWR sky130_fd_sc_hd__tapvpwrvgnd_1
Xhold30 shiftreg_rx\[0\] VGND VGND VPWR VPWR net68 sky130_fd_sc_hd__dlygate4sd3_1
XFILLER_13_3 VGND VGND VPWR VPWR sky130_fd_sc_hd__decap_8
XFILLER_15_54 VGND VGND VPWR VPWR sky130_fd_sc_hd__fill_2
XTAP_TAPCELL_ROW_15_76 VGND VPWR sky130_fd_sc_hd__tapvpwrvgnd_1
Xoutput20 net20 VGND VGND VPWR VPWR data_out[4] sky130_fd_sc_hd__buf_2
XPHY_EDGE_ROW_21_Right_21 VGND VGND VPWR VPWR sky130_fd_sc_hd__decap_3
X_130_ shiftreg_rx\[1\] net59 _040_ VGND VGND VPWR VPWR _012_ sky130_fd_sc_hd__mux2_1
XPHY_EDGE_ROW_12_Right_12 VGND VGND VPWR VPWR sky130_fd_sc_hd__decap_3
Xclkbuf_2_3__f_clkin clknet_0_clkin VGND VGND VPWR VPWR clknet_2_3__leaf_clkin sky130_fd_sc_hd__clkbuf_16
XFILLER_9_23 VGND VGND VPWR VPWR sky130_fd_sc_hd__fill_2
XTAP_TAPCELL_ROW_5_57 VGND VPWR sky130_fd_sc_hd__tapvpwrvgnd_1
X_113_ counter_sclk\[1\] counter_sclk\[0\] VGND VGND VPWR VPWR _050_ sky130_fd_sc_hd__or2_1
XFILLER_1_90 VGND VGND VPWR VPWR sky130_fd_sc_hd__fill_2
Xhold20 shiftreg\[1\] VGND VGND VPWR VPWR net58 sky130_fd_sc_hd__dlygate4sd3_1
Xhold31 shiftreg_rx\[3\] VGND VGND VPWR VPWR net69 sky130_fd_sc_hd__dlygate4sd3_1
XPHY_EDGE_ROW_16_Left_38 VGND VGND VPWR VPWR sky130_fd_sc_hd__decap_3
XPHY_EDGE_ROW_6_Right_6 VGND VGND VPWR VPWR sky130_fd_sc_hd__decap_3
XFILLER_15_11 VGND VGND VPWR VPWR sky130_fd_sc_hd__fill_2
XTAP_TAPCELL_ROW_15_77 VGND VPWR sky130_fd_sc_hd__tapvpwrvgnd_1
Xoutput21 net21 VGND VGND VPWR VPWR data_out[5] sky130_fd_sc_hd__buf_2
XPHY_EDGE_ROW_19_Left_41 VGND VGND VPWR VPWR sky130_fd_sc_hd__decap_3
XFILLER_12_23 VGND VGND VPWR VPWR sky130_fd_sc_hd__decap_4
XPHY_EDGE_ROW_4_Left_26 VGND VGND VPWR VPWR sky130_fd_sc_hd__decap_3
XFILLER_3_3 VPWR VGND VPWR VGND sky130_ef_sc_hd__decap_12
XFILLER_0_15 VPWR VGND VPWR VGND sky130_ef_sc_hd__decap_12
X_189_ clknet_2_0__leaf_clkin net45 net33 VGND VGND VPWR VPWR net20 sky130_fd_sc_hd__dfrtp_1
XFILLER_9_57 VGND VGND VPWR VPWR sky130_fd_sc_hd__decap_6
X_112_ net39 _082_ VGND VGND VPWR VPWR _000_ sky130_fd_sc_hd__nor2_1
Xhold32 mode_internal\[0\] VGND VGND VPWR VPWR net70 sky130_fd_sc_hd__dlygate4sd3_1
Xhold10 net21 VGND VGND VPWR VPWR net48 sky130_fd_sc_hd__dlygate4sd3_1
Xhold21 net17 VGND VGND VPWR VPWR net59 sky130_fd_sc_hd__dlygate4sd3_1
Xoutput22 net22 VGND VGND VPWR VPWR data_out[6] sky130_fd_sc_hd__buf_2
XFILLER_13_103 VGND VGND VPWR VPWR sky130_fd_sc_hd__fill_1
XFILLER_3_15 VGND VGND VPWR VPWR sky130_fd_sc_hd__decap_8
XFILLER_5_7 VGND VGND VPWR VPWR sky130_fd_sc_hd__decap_3
XPHY_EDGE_ROW_20_Left_42 VGND VGND VPWR VPWR sky130_fd_sc_hd__decap_3
XFILLER_0_27 VGND VGND VPWR VPWR sky130_fd_sc_hd__fill_1
X_188_ clknet_2_0__leaf_clkin net53 net33 VGND VGND VPWR VPWR net19 sky130_fd_sc_hd__dfrtp_1
X_111_ net32 net30 shiftreg\[7\] VGND VGND VPWR VPWR net24 sky130_fd_sc_hd__o21a_1
XFILLER_6_59 VPWR VGND VPWR VGND sky130_ef_sc_hd__decap_12
Xhold11 _016_ VGND VGND VPWR VPWR net49 sky130_fd_sc_hd__dlygate4sd3_1
Xhold22 _012_ VGND VGND VPWR VPWR net60 sky130_fd_sc_hd__dlygate4sd3_1
Xhold33 data_count\[0\] VGND VGND VPWR VPWR net71 sky130_fd_sc_hd__dlygate4sd3_1
Xoutput23 net23 VGND VGND VPWR VPWR data_out[7] sky130_fd_sc_hd__buf_2
XFILLER_15_57 VGND VGND VPWR VPWR sky130_fd_sc_hd__fill_2
XFILLER_16_123 VGND VGND VPWR VPWR sky130_fd_sc_hd__decap_4
XFILLER_13_126 VGND VGND VPWR VPWR sky130_fd_sc_hd__fill_2
XFILLER_4_81 VGND VGND VPWR VPWR sky130_fd_sc_hd__decap_3
X_187_ clknet_2_2__leaf_clkin net47 net35 VGND VGND VPWR VPWR net18 sky130_fd_sc_hd__dfrtp_1
Xclkload0 clknet_2_0__leaf_clkin VGND VGND VPWR VPWR clkload0/X sky130_fd_sc_hd__clkbuf_8
X_110_ net31 net30 VGND VGND VPWR VPWR _049_ sky130_fd_sc_hd__nor2_1
Xhold12 net16 VGND VGND VPWR VPWR net50 sky130_fd_sc_hd__dlygate4sd3_1
Xhold23 shiftreg\[2\] VGND VGND VPWR VPWR net61 sky130_fd_sc_hd__dlygate4sd3_1
Xhold34 data_count\[2\] VGND VGND VPWR VPWR net72 sky130_fd_sc_hd__dlygate4sd3_1
XFILLER_6_38 VGND VGND VPWR VPWR sky130_fd_sc_hd__fill_1
XFILLER_10_80 VGND VGND VPWR VPWR sky130_fd_sc_hd__decap_4
Xoutput24 net24 VGND VGND VPWR VPWR mosi sky130_fd_sc_hd__buf_2
XTAP_TAPCELL_ROW_21_90 VGND VPWR sky130_fd_sc_hd__tapvpwrvgnd_1
XPHY_EDGE_ROW_19_Right_19 VGND VGND VPWR VPWR sky130_fd_sc_hd__decap_3
XFILLER_9_109 VGND VGND VPWR VPWR sky130_fd_sc_hd__decap_3
XFILLER_0_29 VGND VGND VPWR VPWR sky130_fd_sc_hd__fill_2
X_186_ clknet_2_2__leaf_clkin net60 net35 VGND VGND VPWR VPWR net17 sky130_fd_sc_hd__dfrtp_1
XFILLER_1_3 VPWR VGND VPWR VGND sky130_ef_sc_hd__decap_12
Xclkload1 clknet_2_2__leaf_clkin VGND VGND VPWR VPWR clkload1/Y sky130_fd_sc_hd__clkinv_2
X_169_ net33 shiftreg_rx\[4\] VGND VGND VPWR VPWR _078_ sky130_fd_sc_hd__and2_1
Xhold35 mode_internal\[1\] VGND VGND VPWR VPWR net73 sky130_fd_sc_hd__dlygate4sd3_1
XFILLER_20_15 VPWR VGND VPWR VGND sky130_ef_sc_hd__decap_12
Xhold24 net22 VGND VGND VPWR VPWR net62 sky130_fd_sc_hd__dlygate4sd3_1
Xhold13 _011_ VGND VGND VPWR VPWR net51 sky130_fd_sc_hd__dlygate4sd3_1
XTAP_TAPCELL_ROW_21_91 VGND VPWR sky130_fd_sc_hd__tapvpwrvgnd_1
XFILLER_21_91 VGND VGND VPWR VPWR sky130_fd_sc_hd__decap_3
Xoutput25 net25 VGND VGND VPWR VPWR sclk sky130_fd_sc_hd__buf_2
XFILLER_12_27 VGND VGND VPWR VPWR sky130_fd_sc_hd__fill_1
XFILLER_5_113 VGND VGND VPWR VPWR sky130_fd_sc_hd__decap_4
X_185_ clknet_2_2__leaf_clkin net51 net35 VGND VGND VPWR VPWR net16 sky130_fd_sc_hd__dfrtp_1
XFILLER_18_26 VGND VGND VPWR VPWR sky130_fd_sc_hd__fill_2
Xclkload2 clknet_2_3__leaf_clkin VGND VGND VPWR VPWR clkload2/Y sky130_fd_sc_hd__clkinv_4
X_168_ net67 _077_ _072_ VGND VGND VPWR VPWR _031_ sky130_fd_sc_hd__mux2_1
X_099_ net30 _042_ VGND VGND VPWR VPWR _043_ sky130_fd_sc_hd__and2_1
Xhold36 data_count\[1\] VGND VGND VPWR VPWR net74 sky130_fd_sc_hd__dlygate4sd3_1
XFILLER_20_27 VGND VGND VPWR VPWR sky130_fd_sc_hd__fill_1
Xhold14 net19 VGND VGND VPWR VPWR net52 sky130_fd_sc_hd__dlygate4sd3_1
Xhold25 shiftreg\[7\] VGND VGND VPWR VPWR net63 sky130_fd_sc_hd__dlygate4sd3_1
XPHY_EDGE_ROW_11_Left_33 VGND VGND VPWR VPWR sky130_fd_sc_hd__decap_3
Xoutput26 net26 VGND VGND VPWR VPWR slave_select[0] sky130_fd_sc_hd__buf_2
XPHY_EDGE_ROW_1_Right_1 VGND VGND VPWR VPWR sky130_fd_sc_hd__decap_3
XFILLER_21_70 VPWR VGND VPWR VGND sky130_ef_sc_hd__decap_12
X_184_ clknet_2_3__leaf_clkin _010_ net38 VGND VGND VPWR VPWR sclk_internal sky130_fd_sc_hd__dfrtp_1
Xclkbuf_0_clkin clkin VGND VGND VPWR VPWR clknet_0_clkin sky130_fd_sc_hd__clkbuf_16
X_098_ mode_internal\[1\] mode_internal\[0\] VGND VGND VPWR VPWR _042_ sky130_fd_sc_hd__xor2_1
X_167_ net33 shiftreg_rx\[3\] VGND VGND VPWR VPWR _077_ sky130_fd_sc_hd__and2_1
XFILLER_19_113 VPWR VGND VPWR VGND sky130_ef_sc_hd__decap_12
Xhold15 _014_ VGND VGND VPWR VPWR net53 sky130_fd_sc_hd__dlygate4sd3_1
Xhold37 counter_sclk\[2\] VGND VGND VPWR VPWR net75 sky130_fd_sc_hd__dlygate4sd3_1
Xhold26 shiftreg_rx\[1\] VGND VGND VPWR VPWR net64 sky130_fd_sc_hd__dlygate4sd3_1
Xoutput27 net27 VGND VGND VPWR VPWR slave_select[1] sky130_fd_sc_hd__buf_2
XFILLER_16_127 VGND VGND VPWR VPWR sky130_fd_sc_hd__fill_1
Xoutput16 net16 VGND VGND VPWR VPWR data_out[0] sky130_fd_sc_hd__buf_2
XFILLER_21_82 VGND VGND VPWR VPWR sky130_fd_sc_hd__fill_2
XFILLER_7_62 VGND VGND VPWR VPWR sky130_fd_sc_hd__decap_6
XPHY_EDGE_ROW_15_Right_15 VGND VGND VPWR VPWR sky130_fd_sc_hd__decap_3
XTAP_TAPCELL_ROW_3_52 VGND VPWR sky130_fd_sc_hd__tapvpwrvgnd_1
XTAP_TAPCELL_ROW_13_72 VGND VPWR sky130_fd_sc_hd__tapvpwrvgnd_1
X_183_ clknet_2_3__leaf_clkin _009_ VGND VGND VPWR VPWR data_count\[2\] sky130_fd_sc_hd__dfxtp_1
XFILLER_20_29 VPWR VGND VPWR VGND sky130_ef_sc_hd__decap_12
X_166_ net69 _076_ _072_ VGND VGND VPWR VPWR _030_ sky130_fd_sc_hd__mux2_1
X_097_ net15 state\[0\] _084_ _041_ net31 VGND VGND VPWR VPWR _006_ sky130_fd_sc_hd__a32o_1
Xhold16 shiftreg\[6\] VGND VGND VPWR VPWR net54 sky130_fd_sc_hd__dlygate4sd3_1
Xhold27 shiftreg_rx\[2\] VGND VGND VPWR VPWR net65 sky130_fd_sc_hd__dlygate4sd3_1
Xhold38 sclk_internal VGND VGND VPWR VPWR net76 sky130_fd_sc_hd__dlygate4sd3_1
XFILLER_19_125 VGND VGND VPWR VPWR sky130_fd_sc_hd__decap_3
X_149_ _065_ net55 _059_ VGND VGND VPWR VPWR _024_ sky130_fd_sc_hd__mux2_1
Xoutput28 net28 VGND VGND VPWR VPWR slave_select[2] sky130_fd_sc_hd__buf_2
Xoutput17 net17 VGND VGND VPWR VPWR data_out[1] sky130_fd_sc_hd__buf_2
XFILLER_7_52 VGND VGND VPWR VPWR sky130_fd_sc_hd__decap_4
XFILLER_16_83 VGND VGND VPWR VPWR sky130_fd_sc_hd__fill_1
XTAP_TAPCELL_ROW_3_53 VGND VPWR sky130_fd_sc_hd__tapvpwrvgnd_1
XFILLER_5_127 VGND VGND VPWR VPWR sky130_fd_sc_hd__fill_1
XTAP_TAPCELL_ROW_13_73 VGND VPWR sky130_fd_sc_hd__tapvpwrvgnd_1
X_182_ clknet_2_3__leaf_clkin _008_ VGND VGND VPWR VPWR data_count\[1\] sky130_fd_sc_hd__dfxtp_1
Xfanout30 sclk_internal VGND VGND VPWR VPWR net30 sky130_fd_sc_hd__buf_2
XFILLER_18_29 VPWR VGND VPWR VGND sky130_ef_sc_hd__decap_12
XFILLER_18_18 VGND VGND VPWR VPWR sky130_fd_sc_hd__decap_8
X_165_ net33 shiftreg_rx\[2\] VGND VGND VPWR VPWR _076_ sky130_fd_sc_hd__and2_1
X_096_ data_count\[0\] data_count\[1\] net78 _085_ VGND VGND VPWR VPWR _041_ sky130_fd_sc_hd__or4_1
Xhold17 shiftreg\[5\] VGND VGND VPWR VPWR net55 sky130_fd_sc_hd__dlygate4sd3_1
Xhold28 shiftreg_rx\[5\] VGND VGND VPWR VPWR net66 sky130_fd_sc_hd__dlygate4sd3_1
Xhold39 counter_sclk\[0\] VGND VGND VPWR VPWR net77 sky130_fd_sc_hd__dlygate4sd3_1
X_148_ net6 shiftreg\[4\] net32 VGND VGND VPWR VPWR _065_ sky130_fd_sc_hd__mux2_1
XFILLER_10_85 VPWR VGND VPWR VGND sky130_ef_sc_hd__decap_12
Xoutput29 net29 VGND VGND VPWR VPWR slave_select[3] sky130_fd_sc_hd__buf_2
Xoutput18 net18 VGND VGND VPWR VPWR data_out[2] sky130_fd_sc_hd__buf_2
XPHY_EDGE_ROW_15_Left_37 VGND VGND VPWR VPWR sky130_fd_sc_hd__decap_3
XPHY_EDGE_ROW_5_Right_5 VGND VGND VPWR VPWR sky130_fd_sc_hd__decap_3
XFILLER_5_117 VGND VGND VPWR VPWR sky130_fd_sc_hd__fill_1
X_181_ clknet_2_3__leaf_clkin _007_ VGND VGND VPWR VPWR data_count\[0\] sky130_fd_sc_hd__dfxtp_1
XPHY_EDGE_ROW_18_Left_40 VGND VGND VPWR VPWR sky130_fd_sc_hd__decap_3
XTAP_TAPCELL_ROW_0_44 VGND VPWR sky130_fd_sc_hd__tapvpwrvgnd_1
Xfanout31 net32 VGND VGND VPWR VPWR net31 sky130_fd_sc_hd__buf_2
XTAP_TAPCELL_ROW_9_64 VGND VPWR sky130_fd_sc_hd__tapvpwrvgnd_1
XPHY_EDGE_ROW_3_Left_25 VGND VGND VPWR VPWR sky130_fd_sc_hd__decap_3
X_164_ net65 _075_ _072_ VGND VGND VPWR VPWR _029_ sky130_fd_sc_hd__mux2_1
X_095_ net76 _040_ _039_ state\[0\] VGND VGND VPWR VPWR _004_ sky130_fd_sc_hd__a2bb2o_1
Xhold29 shiftreg_rx\[4\] VGND VGND VPWR VPWR net67 sky130_fd_sc_hd__dlygate4sd3_1
Xhold18 shiftreg\[4\] VGND VGND VPWR VPWR net56 sky130_fd_sc_hd__dlygate4sd3_1
XTAP_TAPCELL_ROW_19_84 VGND VPWR sky130_fd_sc_hd__tapvpwrvgnd_1
XFILLER_10_42 VGND VGND VPWR VPWR sky130_fd_sc_hd__fill_1
XFILLER_10_64 VGND VGND VPWR VPWR sky130_fd_sc_hd__fill_2
XFILLER_10_97 VGND VGND VPWR VPWR sky130_fd_sc_hd__decap_6
XFILLER_18_3 VGND VGND VPWR VPWR sky130_fd_sc_hd__decap_6
X_147_ _064_ net56 _059_ VGND VGND VPWR VPWR _023_ sky130_fd_sc_hd__mux2_1
XFILLER_21_85 VGND VGND VPWR VPWR sky130_fd_sc_hd__fill_2
XFILLER_21_41 VGND VGND VPWR VPWR sky130_fd_sc_hd__decap_4
Xoutput19 net19 VGND VGND VPWR VPWR data_out[3] sky130_fd_sc_hd__buf_2
XFILLER_7_43 VGND VGND VPWR VPWR sky130_fd_sc_hd__fill_1
XPHY_EDGE_ROW_20_Right_20 VGND VGND VPWR VPWR sky130_fd_sc_hd__decap_3
XPHY_EDGE_ROW_11_Right_11 VGND VGND VPWR VPWR sky130_fd_sc_hd__decap_3
X_180_ clknet_2_1__leaf_clkin _006_ net38 VGND VGND VPWR VPWR state\[2\] sky130_fd_sc_hd__dfrtp_1
Xfanout32 state\[2\] VGND VGND VPWR VPWR net32 sky130_fd_sc_hd__buf_2
XTAP_TAPCELL_ROW_0_45 VGND VPWR sky130_fd_sc_hd__tapvpwrvgnd_1
XTAP_TAPCELL_ROW_9_65 VGND VPWR sky130_fd_sc_hd__tapvpwrvgnd_1
X_163_ net35 shiftreg_rx\[1\] VGND VGND VPWR VPWR _075_ sky130_fd_sc_hd__and2_1
X_094_ state\[1\] _082_ VGND VGND VPWR VPWR _040_ sky130_fd_sc_hd__nand2_4
Xhold19 shiftreg\[3\] VGND VGND VPWR VPWR net57 sky130_fd_sc_hd__dlygate4sd3_1
XTAP_TAPCELL_ROW_19_85 VGND VPWR sky130_fd_sc_hd__tapvpwrvgnd_1
XFILLER_19_106 VGND VGND VPWR VPWR sky130_fd_sc_hd__decap_6
XFILLER_19_74 VGND VGND VPWR VPWR sky130_fd_sc_hd__decap_4
X_146_ net5 shiftreg\[3\] net32 VGND VGND VPWR VPWR _064_ sky130_fd_sc_hd__mux2_1
XFILLER_21_97 VGND VGND VPWR VPWR sky130_fd_sc_hd__decap_4
X_129_ shiftreg_rx\[0\] net50 _040_ VGND VGND VPWR VPWR _011_ sky130_fd_sc_hd__mux2_1
Xclkbuf_2_2__f_clkin clknet_0_clkin VGND VGND VPWR VPWR clknet_2_2__leaf_clkin sky130_fd_sc_hd__clkbuf_16
XFILLER_16_75 VGND VGND VPWR VPWR sky130_fd_sc_hd__fill_1
Xfanout33 net36 VGND VGND VPWR VPWR net33 sky130_fd_sc_hd__buf_2
XTAP_TAPCELL_ROW_0_46 VGND VPWR sky130_fd_sc_hd__tapvpwrvgnd_1
XFILLER_13_65 VGND VGND VPWR VPWR sky130_fd_sc_hd__fill_1
X_093_ net15 _084_ VGND VGND VPWR VPWR _039_ sky130_fd_sc_hd__nand2_1
X_162_ net64 _074_ _072_ VGND VGND VPWR VPWR _028_ sky130_fd_sc_hd__mux2_1
Xinput1 data_in[0] VGND VGND VPWR VPWR net1 sky130_fd_sc_hd__clkbuf_1
XTAP_TAPCELL_ROW_10_66 VGND VPWR sky130_fd_sc_hd__tapvpwrvgnd_1
X_145_ _063_ net57 _059_ VGND VGND VPWR VPWR _022_ sky130_fd_sc_hd__mux2_1
X_214_ clknet_2_2__leaf_clkin _003_ net36 VGND VGND VPWR VPWR rx sky130_fd_sc_hd__dfrtp_1
XFILLER_21_65 VGND VGND VPWR VPWR sky130_fd_sc_hd__fill_1
XFILLER_21_113 VGND VGND VPWR VPWR sky130_fd_sc_hd__fill_2
XFILLER_7_89 VGND VGND VPWR VPWR sky130_fd_sc_hd__fill_2
X_128_ _085_ _052_ VGND VGND VPWR VPWR _010_ sky130_fd_sc_hd__nand2_1
XPHY_EDGE_ROW_9_Right_9 VGND VGND VPWR VPWR sky130_fd_sc_hd__decap_3
XTAP_TAPCELL_ROW_0_47 VGND VPWR sky130_fd_sc_hd__tapvpwrvgnd_1
Xfanout34 net36 VGND VGND VPWR VPWR net34 sky130_fd_sc_hd__clkbuf_2
X_161_ net35 shiftreg_rx\[0\] VGND VGND VPWR VPWR _074_ sky130_fd_sc_hd__and2_1
X_092_ state\[1\] _084_ _038_ VGND VGND VPWR VPWR _005_ sky130_fd_sc_hd__o21a_1
Xinput2 data_in[1] VGND VGND VPWR VPWR net2 sky130_fd_sc_hd__clkbuf_1
XPHY_EDGE_ROW_7_Left_29 VGND VGND VPWR VPWR sky130_fd_sc_hd__decap_3
XFILLER_10_56 VGND VGND VPWR VPWR sky130_fd_sc_hd__decap_8
XTAP_TAPCELL_ROW_10_67 VGND VPWR sky130_fd_sc_hd__tapvpwrvgnd_1
X_213_ clknet_2_2__leaf_clkin _036_ net36 VGND VGND VPWR VPWR mode_internal\[1\] sky130_fd_sc_hd__dfrtp_1
X_144_ net4 shiftreg\[2\] net32 VGND VGND VPWR VPWR _063_ sky130_fd_sc_hd__mux2_1
XTAP_TAPCELL_ROW_21_88 VGND VPWR sky130_fd_sc_hd__tapvpwrvgnd_1
XFILLER_21_55 VGND VGND VPWR VPWR sky130_fd_sc_hd__fill_1
XFILLER_7_68 VGND VGND VPWR VPWR sky130_fd_sc_hd__fill_1
X_127_ state\[0\] net38 _082_ _049_ _058_ VGND VGND VPWR VPWR _009_ sky130_fd_sc_hd__a41o_1
XFILLER_15_122 VGND VGND VPWR VPWR sky130_fd_sc_hd__decap_6
XFILLER_4_121 VGND VGND VPWR VPWR sky130_fd_sc_hd__decap_4
Xfanout35 net36 VGND VGND VPWR VPWR net35 sky130_fd_sc_hd__buf_2
XFILLER_1_15 VGND VGND VPWR VPWR sky130_fd_sc_hd__fill_1
X_160_ net68 _073_ _072_ VGND VGND VPWR VPWR _027_ sky130_fd_sc_hd__mux2_1
X_091_ _084_ _037_ VGND VGND VPWR VPWR _038_ sky130_fd_sc_hd__nand2_1
XPHY_EDGE_ROW_18_Right_18 VGND VGND VPWR VPWR sky130_fd_sc_hd__decap_3
Xinput3 data_in[2] VGND VGND VPWR VPWR net3 sky130_fd_sc_hd__clkbuf_1
XFILLER_19_55 VGND VGND VPWR VPWR sky130_fd_sc_hd__fill_1
X_143_ _062_ net61 _059_ VGND VGND VPWR VPWR _021_ sky130_fd_sc_hd__mux2_1
XTAP_TAPCELL_ROW_6_58 VGND VPWR sky130_fd_sc_hd__tapvpwrvgnd_1
X_212_ clknet_2_2__leaf_clkin _035_ net36 VGND VGND VPWR VPWR mode_internal\[0\] sky130_fd_sc_hd__dfrtp_1
XTAP_TAPCELL_ROW_21_89 VGND VPWR sky130_fd_sc_hd__tapvpwrvgnd_1
X_126_ data_count\[0\] data_count\[1\] _053_ net72 VGND VGND VPWR VPWR _058_ sky130_fd_sc_hd__o31a_1
XFILLER_21_126 VGND VGND VPWR VPWR sky130_fd_sc_hd__fill_2
XPHY_EDGE_ROW_10_Left_32 VGND VGND VPWR VPWR sky130_fd_sc_hd__decap_3
XTAP_TAPCELL_ROW_16_78 VGND VPWR sky130_fd_sc_hd__tapvpwrvgnd_1
XPHY_EDGE_ROW_0_Right_0 VGND VGND VPWR VPWR sky130_fd_sc_hd__decap_3
XFILLER_12_126 VGND VGND VPWR VPWR sky130_fd_sc_hd__fill_2
X_109_ net14 net13 _048_ VGND VGND VPWR VPWR net29 sky130_fd_sc_hd__nand3_1
Xfanout36 net12 VGND VGND VPWR VPWR net36 sky130_fd_sc_hd__clkbuf_2
XFILLER_6_3 VGND VGND VPWR VPWR sky130_fd_sc_hd__decap_3
X_090_ data_count\[0\] data_count\[1\] data_count\[2\] net31 VGND VGND VPWR VPWR _037_
+ sky130_fd_sc_hd__or4b_1
Xinput4 data_in[3] VGND VGND VPWR VPWR net4 sky130_fd_sc_hd__clkbuf_1
XFILLER_19_45 VGND VGND VPWR VPWR sky130_fd_sc_hd__fill_1
X_142_ net3 shiftreg\[1\] net32 VGND VGND VPWR VPWR _062_ sky130_fd_sc_hd__mux2_1
X_211_ clknet_2_0__leaf_clkin _034_ net34 VGND VGND VPWR VPWR shiftreg_rx\[7\] sky130_fd_sc_hd__dfrtp_1
XTAP_TAPCELL_ROW_6_59 VGND VPWR sky130_fd_sc_hd__tapvpwrvgnd_1
XFILLER_21_57 VGND VGND VPWR VPWR sky130_fd_sc_hd__decap_8
X_125_ _057_ _053_ net74 _054_ VGND VGND VPWR VPWR _008_ sky130_fd_sc_hd__a2bb2o_1
XFILLER_21_105 VGND VGND VPWR VPWR sky130_fd_sc_hd__decap_3
XTAP_TAPCELL_ROW_16_79 VGND VPWR sky130_fd_sc_hd__tapvpwrvgnd_1
XFILLER_16_46 VPWR VGND VPWR VGND sky130_ef_sc_hd__decap_12
XFILLER_21_3 VPWR VGND VPWR VGND sky130_ef_sc_hd__decap_12
X_108_ net13 _048_ net14 VGND VGND VPWR VPWR net28 sky130_fd_sc_hd__nand3b_1
Xfanout37 net38 VGND VGND VPWR VPWR net37 sky130_fd_sc_hd__clkbuf_4
XFILLER_13_47 VGND VGND VPWR VPWR sky130_fd_sc_hd__decap_6
XFILLER_5_70 VPWR VGND VPWR VGND sky130_ef_sc_hd__decap_12
Xinput5 data_in[4] VGND VGND VPWR VPWR net5 sky130_fd_sc_hd__clkbuf_1
XFILLER_18_9 VGND VGND VPWR VPWR sky130_fd_sc_hd__fill_1
X_141_ _061_ net58 _059_ VGND VGND VPWR VPWR _020_ sky130_fd_sc_hd__mux2_1
X_210_ clknet_2_0__leaf_clkin _033_ net34 VGND VGND VPWR VPWR shiftreg_rx\[6\] sky130_fd_sc_hd__dfrtp_1
X_124_ data_count\[0\] data_count\[1\] net31 VGND VGND VPWR VPWR _057_ sky130_fd_sc_hd__o21a_1
XFILLER_16_58 VGND VGND VPWR VPWR sky130_fd_sc_hd__fill_1
X_107_ net14 net13 _048_ VGND VGND VPWR VPWR net27 sky130_fd_sc_hd__nand3b_1
XFILLER_14_3 VGND VGND VPWR VPWR sky130_fd_sc_hd__decap_4
Xfanout38 net12 VGND VGND VPWR VPWR net38 sky130_fd_sc_hd__buf_2
XFILLER_5_82 VGND VGND VPWR VPWR sky130_fd_sc_hd__fill_1
Xinput6 data_in[5] VGND VGND VPWR VPWR net6 sky130_fd_sc_hd__clkbuf_1
XFILLER_10_27 VGND VGND VPWR VPWR sky130_fd_sc_hd__fill_1
XFILLER_18_101 VPWR VGND VPWR VGND sky130_ef_sc_hd__decap_12
X_140_ net2 shiftreg\[0\] net32 VGND VGND VPWR VPWR _061_ sky130_fd_sc_hd__mux2_1
XPHY_EDGE_ROW_14_Right_14 VGND VGND VPWR VPWR sky130_fd_sc_hd__decap_3
XFILLER_21_48 VGND VGND VPWR VPWR sky130_fd_sc_hd__decap_4
XFILLER_21_15 VPWR VGND VPWR VGND sky130_ef_sc_hd__decap_12
XFILLER_21_118 VGND VGND VPWR VPWR sky130_fd_sc_hd__decap_4
XTAP_TAPCELL_ROW_7_60 VGND VPWR sky130_fd_sc_hd__tapvpwrvgnd_1
X_123_ _054_ _056_ VGND VGND VPWR VPWR _007_ sky130_fd_sc_hd__nand2_1
X_106_ net14 net13 _048_ VGND VGND VPWR VPWR net26 sky130_fd_sc_hd__or3b_1
XFILLER_7_122 VGND VGND VPWR VPWR sky130_fd_sc_hd__decap_3
XPHY_EDGE_ROW_4_Right_4 VGND VGND VPWR VPWR sky130_fd_sc_hd__decap_3
XPHY_EDGE_ROW_14_Left_36 VGND VGND VPWR VPWR sky130_fd_sc_hd__decap_3
XFILLER_4_29 VGND VGND VPWR VPWR sky130_fd_sc_hd__decap_4
XTAP_TAPCELL_ROW_17_80 VGND VPWR sky130_fd_sc_hd__tapvpwrvgnd_1
XFILLER_5_61 VGND VGND VPWR VPWR sky130_fd_sc_hd__fill_1
Xinput7 data_in[6] VGND VGND VPWR VPWR net7 sky130_fd_sc_hd__clkbuf_1
XFILLER_19_15 VPWR VGND VPWR VGND sky130_ef_sc_hd__decap_12
XFILLER_4_3 VGND VGND VPWR VPWR sky130_fd_sc_hd__decap_4
XPHY_EDGE_ROW_2_Left_24 VGND VGND VPWR VPWR sky130_fd_sc_hd__decap_3
XFILLER_18_113 VPWR VGND VPWR VGND sky130_ef_sc_hd__decap_12
X_199_ clknet_2_1__leaf_clkin _025_ net37 VGND VGND VPWR VPWR shiftreg\[6\] sky130_fd_sc_hd__dfrtp_1
XFILLER_21_27 VGND VGND VPWR VPWR sky130_fd_sc_hd__fill_1
XTAP_TAPCELL_ROW_7_61 VGND VPWR sky130_fd_sc_hd__tapvpwrvgnd_1
XFILLER_11_93 VGND VGND VPWR VPWR sky130_fd_sc_hd__decap_4
X_122_ _085_ _055_ net71 VGND VGND VPWR VPWR _056_ sky130_fd_sc_hd__o21ai_1
Xinput10 mode[0] VGND VGND VPWR VPWR net10 sky130_fd_sc_hd__clkbuf_1
XFILLER_16_27 VGND VGND VPWR VPWR sky130_fd_sc_hd__fill_1
X_105_ _046_ _047_ net30 VGND VGND VPWR VPWR _048_ sky130_fd_sc_hd__mux2_1
XTAP_TAPCELL_ROW_17_81 VGND VPWR sky130_fd_sc_hd__tapvpwrvgnd_1
Xinput8 data_in[7] VGND VGND VPWR VPWR net8 sky130_fd_sc_hd__clkbuf_1
XFILLER_19_27 VPWR VGND VPWR VGND sky130_ef_sc_hd__decap_12
XFILLER_18_125 VGND VGND VPWR VPWR sky130_fd_sc_hd__decap_3
X_198_ clknet_2_1__leaf_clkin _024_ net37 VGND VGND VPWR VPWR shiftreg\[5\] sky130_fd_sc_hd__dfrtp_1
X_121_ net31 net38 VGND VGND VPWR VPWR _055_ sky130_fd_sc_hd__nand2_1
Xinput11 mode[1] VGND VGND VPWR VPWR net11 sky130_fd_sc_hd__clkbuf_1
X_104_ net31 state\[1\] state\[0\] VGND VGND VPWR VPWR _047_ sky130_fd_sc_hd__o21ba_1
Xinput9 miso VGND VGND VPWR VPWR net9 sky130_fd_sc_hd__clkbuf_1
XFILLER_19_39 VGND VGND VPWR VPWR sky130_fd_sc_hd__decap_6
X_197_ clknet_2_1__leaf_clkin _023_ net37 VGND VGND VPWR VPWR shiftreg\[4\] sky130_fd_sc_hd__dfrtp_1
XFILLER_21_29 VPWR VGND VPWR VGND sky130_ef_sc_hd__decap_12
XFILLER_2_97 VGND VGND VPWR VPWR sky130_fd_sc_hd__decap_3
XPHY_EDGE_ROW_10_Right_10 VGND VGND VPWR VPWR sky130_fd_sc_hd__decap_3
X_120_ data_count\[0\] _053_ VGND VGND VPWR VPWR _054_ sky130_fd_sc_hd__or2_1
Xinput12 reset VGND VGND VPWR VPWR net12 sky130_fd_sc_hd__buf_1
XFILLER_11_121 VGND VGND VPWR VPWR sky130_fd_sc_hd__decap_4
XFILLER_14_7 VGND VGND VPWR VPWR sky130_fd_sc_hd__fill_1
X_103_ net31 net15 state\[0\] VGND VGND VPWR VPWR _046_ sky130_fd_sc_hd__mux2_1
XFILLER_8_41 VGND VGND VPWR VPWR sky130_fd_sc_hd__fill_1
XPHY_EDGE_ROW_8_Right_8 VGND VGND VPWR VPWR sky130_fd_sc_hd__decap_3
Xhold1 counter_sclk\[0\] VGND VGND VPWR VPWR net39 sky130_fd_sc_hd__dlygate4sd3_1
XFILLER_5_53 VGND VGND VPWR VPWR sky130_fd_sc_hd__decap_3
XFILLER_14_73 VGND VGND VPWR VPWR sky130_fd_sc_hd__fill_2
X_196_ clknet_2_1__leaf_clkin _022_ net37 VGND VGND VPWR VPWR shiftreg\[3\] sky130_fd_sc_hd__dfrtp_1
XPHY_EDGE_ROW_6_Left_28 VGND VGND VPWR VPWR sky130_fd_sc_hd__decap_3
Xinput13 slave_select_in[0] VGND VGND VPWR VPWR net13 sky130_fd_sc_hd__buf_1
XFILLER_2_3 VPWR VGND VPWR VGND sky130_ef_sc_hd__decap_12
X_179_ clknet_2_3__leaf_clkin _005_ net38 VGND VGND VPWR VPWR state\[1\] sky130_fd_sc_hd__dfrtp_2
X_102_ net31 state\[0\] VGND VGND VPWR VPWR _045_ sky130_fd_sc_hd__nor2_1
XPHY_EDGE_ROW_9_Left_31 VGND VGND VPWR VPWR sky130_fd_sc_hd__decap_3
XFILLER_17_73 VGND VGND VPWR VPWR sky130_fd_sc_hd__decap_4
Xhold2 shiftreg_rx\[7\] VGND VGND VPWR VPWR net40 sky130_fd_sc_hd__dlygate4sd3_1
XTAP_TAPCELL_ROW_4_54 VGND VPWR sky130_fd_sc_hd__tapvpwrvgnd_1
XTAP_TAPCELL_ROW_14_74 VGND VPWR sky130_fd_sc_hd__tapvpwrvgnd_1
XFILLER_4_7 VGND VGND VPWR VPWR sky130_fd_sc_hd__fill_1
X_195_ clknet_2_1__leaf_clkin _021_ net37 VGND VGND VPWR VPWR shiftreg\[2\] sky130_fd_sc_hd__dfrtp_1
Xclkbuf_2_1__f_clkin clknet_0_clkin VGND VGND VPWR VPWR clknet_2_1__leaf_clkin sky130_fd_sc_hd__clkbuf_16
Xinput14 slave_select_in[1] VGND VGND VPWR VPWR net14 sky130_fd_sc_hd__buf_1
XFILLER_11_97 VGND VGND VPWR VPWR sky130_fd_sc_hd__fill_1
X_178_ clknet_2_3__leaf_clkin _004_ net38 VGND VGND VPWR VPWR state\[0\] sky130_fd_sc_hd__dfstp_1
X_101_ net31 mode_internal\[1\] _043_ _044_ net35 VGND VGND VPWR VPWR net25 sky130_fd_sc_hd__o221a_1
XTAP_TAPCELL_ROW_4_55 VGND VPWR sky130_fd_sc_hd__tapvpwrvgnd_1
Xhold3 _018_ VGND VGND VPWR VPWR net41 sky130_fd_sc_hd__dlygate4sd3_1
XFILLER_5_99 VGND VGND VPWR VPWR sky130_fd_sc_hd__decap_4
XTAP_TAPCELL_ROW_14_75 VGND VPWR sky130_fd_sc_hd__tapvpwrvgnd_1
X_194_ clknet_2_1__leaf_clkin _020_ net37 VGND VGND VPWR VPWR shiftreg\[1\] sky130_fd_sc_hd__dfrtp_1
X_177_ net73 net11 _081_ VGND VGND VPWR VPWR _036_ sky130_fd_sc_hd__mux2_1
Xinput15 tx_enable VGND VGND VPWR VPWR net15 sky130_fd_sc_hd__buf_1
XFILLER_11_113 VGND VGND VPWR VPWR sky130_fd_sc_hd__fill_2
X_100_ net30 _042_ net31 VGND VGND VPWR VPWR _044_ sky130_fd_sc_hd__o21ai_1
XFILLER_8_99 VGND VGND VPWR VPWR sky130_fd_sc_hd__fill_1
Xhold4 shiftreg_rx\[6\] VGND VGND VPWR VPWR net42 sky130_fd_sc_hd__dlygate4sd3_1
XPHY_EDGE_ROW_17_Right_17 VGND VGND VPWR VPWR sky130_fd_sc_hd__decap_3
X_193_ clknet_2_1__leaf_clkin _019_ net37 VGND VGND VPWR VPWR shiftreg\[0\] sky130_fd_sc_hd__dfrtp_1
XFILLER_11_55 VGND VGND VPWR VPWR sky130_fd_sc_hd__fill_1
XFILLER_11_77 VGND VGND VPWR VPWR sky130_fd_sc_hd__decap_8
X_176_ net70 net10 _081_ VGND VGND VPWR VPWR _035_ sky130_fd_sc_hd__mux2_1
XFILLER_14_111 VGND VGND VPWR VPWR sky130_fd_sc_hd__fill_1
XFILLER_0_3 VPWR VGND VPWR VGND sky130_ef_sc_hd__decap_12
X_159_ net35 net9 VGND VGND VPWR VPWR _073_ sky130_fd_sc_hd__and2_1
XFILLER_17_10 VGND VGND VPWR VPWR sky130_fd_sc_hd__fill_1
XFILLER_17_32 VGND VGND VPWR VPWR sky130_fd_sc_hd__decap_4
Xhold5 shiftreg\[0\] VGND VGND VPWR VPWR net43 sky130_fd_sc_hd__dlygate4sd3_1
XFILLER_0_113 VGND VGND VPWR VPWR sky130_fd_sc_hd__fill_2
XFILLER_5_57 VGND VGND VPWR VPWR sky130_fd_sc_hd__decap_4
X_192_ clknet_2_0__leaf_clkin net41 net34 VGND VGND VPWR VPWR net23 sky130_fd_sc_hd__dfrtp_1
X_175_ net30 state\[1\] _082_ VGND VGND VPWR VPWR _081_ sky130_fd_sc_hd__and3_1
X_158_ _068_ _070_ _071_ VGND VGND VPWR VPWR _072_ sky130_fd_sc_hd__o21ba_2
X_089_ net30 _083_ VGND VGND VPWR VPWR _085_ sky130_fd_sc_hd__or2_1
Xhold6 net20 VGND VGND VPWR VPWR net44 sky130_fd_sc_hd__dlygate4sd3_1
XPHY_EDGE_ROW_3_Right_3 VGND VGND VPWR VPWR sky130_fd_sc_hd__decap_3
XPHY_EDGE_ROW_13_Left_35 VGND VGND VPWR VPWR sky130_fd_sc_hd__decap_3
XTAP_TAPCELL_ROW_1_48 VGND VPWR sky130_fd_sc_hd__tapvpwrvgnd_1
XFILLER_2_15 VGND VGND VPWR VPWR sky130_fd_sc_hd__decap_4
X_191_ clknet_2_0__leaf_clkin _017_ net33 VGND VGND VPWR VPWR net22 sky130_fd_sc_hd__dfrtp_1
XTAP_TAPCELL_ROW_11_68 VGND VPWR sky130_fd_sc_hd__tapvpwrvgnd_1
X_174_ net40 _080_ _072_ VGND VGND VPWR VPWR _034_ sky130_fd_sc_hd__mux2_1
XPHY_EDGE_ROW_1_Left_23 VGND VGND VPWR VPWR sky130_fd_sc_hd__decap_3
XFILLER_20_116 VPWR VGND VPWR VGND sky130_ef_sc_hd__decap_12
XFILLER_19_3 VPWR VGND VPWR VGND sky130_ef_sc_hd__decap_12
X_088_ net30 _083_ VGND VGND VPWR VPWR _084_ sky130_fd_sc_hd__nor2_1
X_157_ net38 _040_ _045_ _083_ VGND VGND VPWR VPWR _071_ sky130_fd_sc_hd__o22a_1
Xhold7 _015_ VGND VGND VPWR VPWR net45 sky130_fd_sc_hd__dlygate4sd3_1
X_209_ clknet_2_0__leaf_clkin _032_ net34 VGND VGND VPWR VPWR shiftreg_rx\[5\] sky130_fd_sc_hd__dfrtp_1
XFILLER_10_7 VGND VGND VPWR VPWR sky130_fd_sc_hd__decap_3
XPHY_EDGE_ROW_13_Right_13 VGND VGND VPWR VPWR sky130_fd_sc_hd__decap_3
XTAP_TAPCELL_ROW_1_49 VGND VPWR sky130_fd_sc_hd__tapvpwrvgnd_1
XFILLER_2_38 VGND VGND VPWR VPWR sky130_fd_sc_hd__decap_6
X_190_ clknet_2_0__leaf_clkin net49 net33 VGND VGND VPWR VPWR net21 sky130_fd_sc_hd__dfrtp_1
XTAP_TAPCELL_ROW_11_69 VGND VPWR sky130_fd_sc_hd__tapvpwrvgnd_1
X_173_ net33 shiftreg_rx\[6\] VGND VGND VPWR VPWR _080_ sky130_fd_sc_hd__and2_1
XFILLER_11_106 VGND VGND VPWR VPWR sky130_fd_sc_hd__decap_6
XFILLER_8_59 VGND VGND VPWR VPWR sky130_fd_sc_hd__fill_1
X_087_ counter_sclk\[1\] counter_sclk\[2\] VGND VGND VPWR VPWR _083_ sky130_fd_sc_hd__or2_1
X_156_ net25 _069_ _055_ VGND VGND VPWR VPWR _070_ sky130_fd_sc_hd__a21o_1
XFILLER_3_124 VGND VGND VPWR VPWR sky130_fd_sc_hd__decap_4
XFILLER_3_113 VGND VGND VPWR VPWR sky130_fd_sc_hd__fill_2
XFILLER_3_102 VGND VGND VPWR VPWR sky130_fd_sc_hd__fill_1
Xhold8 net18 VGND VGND VPWR VPWR net46 sky130_fd_sc_hd__dlygate4sd3_1
XFILLER_17_57 VGND VGND VPWR VPWR sky130_fd_sc_hd__fill_2
X_208_ clknet_2_0__leaf_clkin _031_ net33 VGND VGND VPWR VPWR shiftreg_rx\[4\] sky130_fd_sc_hd__dfrtp_1
X_139_ net43 _059_ _060_ VGND VGND VPWR VPWR _019_ sky130_fd_sc_hd__a21bo_1
XFILLER_0_127 VGND VGND VPWR VPWR sky130_fd_sc_hd__fill_1
XFILLER_6_81 VGND VGND VPWR VPWR sky130_fd_sc_hd__decap_3
XFILLER_9_3 VGND VGND VPWR VPWR sky130_fd_sc_hd__decap_3
X_172_ net42 _079_ _072_ VGND VGND VPWR VPWR _033_ sky130_fd_sc_hd__mux2_1
XFILLER_3_71 VGND VGND VPWR VPWR sky130_fd_sc_hd__fill_2
XFILLER_8_27 VGND VGND VPWR VPWR sky130_fd_sc_hd__fill_1
X_086_ counter_sclk\[1\] counter_sclk\[2\] VGND VGND VPWR VPWR _082_ sky130_fd_sc_hd__nor2_2
XFILLER_12_80 VGND VGND VPWR VPWR sky130_fd_sc_hd__decap_4
X_155_ rx _042_ VGND VGND VPWR VPWR _069_ sky130_fd_sc_hd__nor2_1
Xhold9 _013_ VGND VGND VPWR VPWR net47 sky130_fd_sc_hd__dlygate4sd3_1
X_138_ _059_ net32 net1 VGND VGND VPWR VPWR _060_ sky130_fd_sc_hd__or3b_1
X_207_ clknet_2_0__leaf_clkin _030_ net34 VGND VGND VPWR VPWR shiftreg_rx\[3\] sky130_fd_sc_hd__dfrtp_1
XPHY_EDGE_ROW_17_Left_39 VGND VGND VPWR VPWR sky130_fd_sc_hd__decap_3
XPHY_EDGE_ROW_7_Right_7 VGND VGND VPWR VPWR sky130_fd_sc_hd__decap_3
XFILLER_6_71 VGND VGND VPWR VPWR sky130_fd_sc_hd__decap_3
XTAP_TAPCELL_ROW_2_50 VGND VPWR sky130_fd_sc_hd__tapvpwrvgnd_1
XFILLER_17_113 VPWR VGND VPWR VGND sky130_ef_sc_hd__decap_12
XFILLER_11_27 VGND VGND VPWR VPWR sky130_fd_sc_hd__fill_2
XFILLER_11_49 VGND VGND VPWR VPWR sky130_fd_sc_hd__decap_6
X_171_ net33 shiftreg_rx\[5\] VGND VGND VPWR VPWR _079_ sky130_fd_sc_hd__and2_1
XFILLER_14_127 VGND VGND VPWR VPWR sky130_fd_sc_hd__fill_1
XPHY_EDGE_ROW_5_Left_27 VGND VGND VPWR VPWR sky130_fd_sc_hd__decap_3
XTAP_TAPCELL_ROW_12_70 VGND VPWR sky130_fd_sc_hd__tapvpwrvgnd_1
X_154_ net25 rx _042_ VGND VGND VPWR VPWR _068_ sky130_fd_sc_hd__and3b_1
X_206_ clknet_2_2__leaf_clkin _029_ net35 VGND VGND VPWR VPWR shiftreg_rx\[2\] sky130_fd_sc_hd__dfrtp_1
X_137_ net30 _083_ _046_ VGND VGND VPWR VPWR _059_ sky130_fd_sc_hd__or3b_4
XFILLER_5_18 VGND VGND VPWR VPWR sky130_fd_sc_hd__fill_1
XPHY_EDGE_ROW_8_Left_30 VGND VGND VPWR VPWR sky130_fd_sc_hd__decap_3
XFILLER_14_38 VGND VGND VPWR VPWR sky130_fd_sc_hd__decap_4
XFILLER_20_81 VGND VGND VPWR VPWR sky130_fd_sc_hd__decap_3
XTAP_TAPCELL_ROW_2_51 VGND VPWR sky130_fd_sc_hd__tapvpwrvgnd_1
XFILLER_2_19 VGND VGND VPWR VPWR sky130_fd_sc_hd__fill_1
XFILLER_17_125 VGND VGND VPWR VPWR sky130_fd_sc_hd__decap_3
X_170_ net66 _078_ _072_ VGND VGND VPWR VPWR _032_ sky130_fd_sc_hd__mux2_1
XPHY_EDGE_ROW_21_Left_43 VGND VGND VPWR VPWR sky130_fd_sc_hd__decap_3
XTAP_TAPCELL_ROW_12_71 VGND VPWR sky130_fd_sc_hd__tapvpwrvgnd_1
X_153_ _067_ net63 _059_ VGND VGND VPWR VPWR _026_ sky130_fd_sc_hd__mux2_1
XFILLER_12_93 VGND VGND VPWR VPWR sky130_fd_sc_hd__fill_2
X_136_ net40 net23 _040_ VGND VGND VPWR VPWR _018_ sky130_fd_sc_hd__mux2_1
X_205_ clknet_2_2__leaf_clkin _028_ net35 VGND VGND VPWR VPWR shiftreg_rx\[1\] sky130_fd_sc_hd__dfrtp_1
XFILLER_18_70 VPWR VGND VPWR VGND sky130_ef_sc_hd__decap_12
X_119_ _045_ _038_ net38 VGND VGND VPWR VPWR _053_ sky130_fd_sc_hd__or3b_1
XFILLER_17_104 VGND VGND VPWR VPWR sky130_fd_sc_hd__decap_8
XFILLER_9_122 VGND VGND VPWR VPWR sky130_fd_sc_hd__decap_6
X_152_ net8 shiftreg\[6\] net32 VGND VGND VPWR VPWR _067_ sky130_fd_sc_hd__mux2_1
XTAP_TAPCELL_ROW_8_62 VGND VPWR sky130_fd_sc_hd__tapvpwrvgnd_1
X_204_ clknet_2_2__leaf_clkin _027_ net35 VGND VGND VPWR VPWR shiftreg_rx\[0\] sky130_fd_sc_hd__dfrtp_1
X_135_ net42 net62 _040_ VGND VGND VPWR VPWR _017_ sky130_fd_sc_hd__mux2_1
XTAP_TAPCELL_ROW_18_82 VGND VPWR sky130_fd_sc_hd__tapvpwrvgnd_1
XFILLER_18_82 VGND VGND VPWR VPWR sky130_fd_sc_hd__fill_2
X_118_ _082_ net25 _052_ VGND VGND VPWR VPWR _003_ sky130_fd_sc_hd__a21bo_1
XFILLER_20_61 VPWR VGND VPWR VGND sky130_ef_sc_hd__decap_12
XFILLER_6_85 VGND VGND VPWR VPWR sky130_fd_sc_hd__fill_1
XFILLER_9_101 VGND VGND VPWR VPWR sky130_fd_sc_hd__decap_8
XFILLER_6_126 VGND VGND VPWR VPWR sky130_fd_sc_hd__fill_2
X_151_ _066_ net54 _059_ VGND VGND VPWR VPWR _025_ sky130_fd_sc_hd__mux2_1
XFILLER_12_51 VGND VGND VPWR VPWR sky130_fd_sc_hd__decap_4
XTAP_TAPCELL_ROW_8_63 VGND VPWR sky130_fd_sc_hd__tapvpwrvgnd_1
XFILLER_0_43 VGND VGND VPWR VPWR sky130_fd_sc_hd__fill_1
X_203_ clknet_2_1__leaf_clkin _002_ net37 VGND VGND VPWR VPWR counter_sclk\[2\] sky130_fd_sc_hd__dfstp_1
X_134_ shiftreg_rx\[5\] net48 _040_ VGND VGND VPWR VPWR _016_ sky130_fd_sc_hd__mux2_1
XTAP_TAPCELL_ROW_18_83 VGND VPWR sky130_fd_sc_hd__tapvpwrvgnd_1
X_117_ net30 _083_ VGND VGND VPWR VPWR _052_ sky130_fd_sc_hd__nand2_1
XFILLER_20_73 VGND VGND VPWR VPWR sky130_fd_sc_hd__decap_8
Xclkbuf_2_0__f_clkin clknet_0_clkin VGND VGND VPWR VPWR clknet_2_0__leaf_clkin sky130_fd_sc_hd__clkbuf_16
X_150_ net7 shiftreg\[5\] net32 VGND VGND VPWR VPWR _066_ sky130_fd_sc_hd__mux2_1
XPHY_EDGE_ROW_16_Right_16 VGND VGND VPWR VPWR sky130_fd_sc_hd__decap_3
X_133_ shiftreg_rx\[4\] net44 _040_ VGND VGND VPWR VPWR _015_ sky130_fd_sc_hd__mux2_1
X_202_ clknet_2_1__leaf_clkin _001_ net37 VGND VGND VPWR VPWR counter_sclk\[1\] sky130_fd_sc_hd__dfrtp_1
X_116_ net75 _050_ _082_ VGND VGND VPWR VPWR _002_ sky130_fd_sc_hd__a21o_1
XPHY_EDGE_ROW_12_Left_34 VGND VGND VPWR VPWR sky130_fd_sc_hd__decap_3
XPHY_EDGE_ROW_2_Right_2 VGND VGND VPWR VPWR sky130_fd_sc_hd__decap_3
XFILLER_20_85 VPWR VGND VPWR VGND sky130_ef_sc_hd__decap_12
XFILLER_20_41 VPWR VGND VPWR VGND sky130_ef_sc_hd__decap_12
XPHY_EDGE_ROW_0_Left_22 VGND VGND VPWR VPWR sky130_fd_sc_hd__decap_3
XFILLER_12_75 VGND VGND VPWR VPWR sky130_fd_sc_hd__fill_1
X_132_ shiftreg_rx\[3\] net52 _040_ VGND VGND VPWR VPWR _014_ sky130_fd_sc_hd__mux2_1
X_201_ clknet_2_1__leaf_clkin _000_ net37 VGND VGND VPWR VPWR counter_sclk\[0\] sky130_fd_sc_hd__dfrtp_1
XFILLER_18_41 VGND VGND VPWR VPWR sky130_fd_sc_hd__fill_2
X_115_ _050_ _051_ _082_ VGND VGND VPWR VPWR _001_ sky130_fd_sc_hd__a21oi_1
XTAP_TAPCELL_ROW_20_86 VGND VPWR sky130_fd_sc_hd__tapvpwrvgnd_1
Xhold40 data_count\[2\] VGND VGND VPWR VPWR net78 sky130_fd_sc_hd__dlygate4sd3_1
XFILLER_20_3 VPWR VGND VPWR VGND sky130_ef_sc_hd__decap_12
XFILLER_15_42 VPWR VGND VPWR VGND sky130_ef_sc_hd__decap_12
XFILLER_15_75 VGND VGND VPWR VPWR sky130_fd_sc_hd__fill_1
.ends
